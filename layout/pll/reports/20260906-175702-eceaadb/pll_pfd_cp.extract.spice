* extracted by klt extract --deck sky130

* cell pll_pfd_cp
* pin vsubs
.SUBCKT pll_pfd_cp vsubs
* device instance $1 r0 *1 0.545,0.5 nfet
M$1 \$20 \$18 \$17 vsubs nfet L=0.15U W=1U AS=0.47P AD=0.47P PS=2.94U PD=2.94U
* device instance $2 r0 *1 2.035,0.5 nfet
M$2 \$26 \$24 \$22 vsubs nfet L=0.15U W=1U AS=0.47P AD=0.47P PS=2.94U PD=2.94U
* device instance $3 r0 *1 3.525,0.5 nfet
M$3 \$32 \$1 \$28 vsubs nfet L=0.15U W=1U AS=0.47P AD=0.47P PS=2.94U PD=2.94U
* device instance $4 r0 *1 5.015,0.5 nfet
M$4 \$37 \$35 \$34 vsubs nfet L=0.15U W=1U AS=0.47P AD=0.47P PS=2.94U PD=2.94U
* device instance $5 r0 *1 6.505,0.5 nfet
M$5 \$42 \$41 \$40 vsubs nfet L=0.15U W=1U AS=0.47P AD=0.47P PS=2.94U PD=2.94U
* device instance $6 r0 *1 7.995,0.5 nfet
M$6 \$48 \$46 \$45 vsubs nfet L=0.15U W=1U AS=0.47P AD=0.47P PS=2.94U PD=2.94U
* device instance $7 r0 *1 13.11,0.5 nfet
M$7 \$52 \$51 \$50 vsubs nfet L=0.3U W=1U AS=0.42P AD=0.42P PS=2.84U PD=2.84U
* device instance $8 r0 *1 14.65,0.5 nfet
M$8 \$57 \$56 \$54 vsubs nfet L=0.3U W=1U AS=0.42P AD=0.42P PS=2.84U PD=2.84U
* device instance $9 r0 *1 16.19,0.5 nfet
M$9 \$63 \$62 \$60 vsubs nfet L=0.3U W=1U AS=0.42P AD=0.42P PS=2.84U PD=2.84U
* device instance $10 r0 *1 21.68,0.5 nfet
M$10 \$66 \$2 \$65 vsubs nfet L=1U W=1U AS=0.42P AD=0.42P PS=2.84U PD=2.84U
* device instance $11 r0 *1 23.92,0.5 nfet
M$11 \$68 \$3 \$67 vsubs nfet L=1U W=1U AS=0.42P AD=0.42P PS=2.84U PD=2.84U
* device instance $12 r0 *1 29.76,1 nfet
M$12 \$70 \$4 \$69 vsubs nfet L=1U W=2U AS=0.84P AD=0.84P PS=4.84U PD=4.84U
* device instance $13 r0 *1 32,1 nfet
M$13 \$72 \$5 \$71 vsubs nfet L=1U W=2U AS=0.84P AD=0.84P PS=4.84U PD=4.84U
* device instance $14 r0 *1 0.545,2.72 nfet
M$14 \$21 \$19 \$16 vsubs nfet L=0.15U W=1U AS=0.47P AD=0.47P PS=2.94U PD=2.94U
* device instance $15 r0 *1 2.035,2.72 nfet
M$15 \$27 \$25 \$23 vsubs nfet L=0.15U W=1U AS=0.47P AD=0.47P PS=2.94U PD=2.94U
* device instance $16 r0 *1 3.525,2.72 nfet
M$16 \$31 \$30 \$29 vsubs nfet L=0.15U W=1U AS=0.47P AD=0.47P PS=2.94U PD=2.94U
* device instance $17 r0 *1 5.015,2.72 nfet
M$17 \$38 \$36 \$33 vsubs nfet L=0.15U W=1U AS=0.47P AD=0.47P PS=2.94U PD=2.94U
* device instance $18 r0 *1 6.505,2.72 nfet
M$18 \$43 \$121 \$39 vsubs nfet L=0.15U W=1U AS=0.47P AD=0.47P PS=2.94U PD=2.94U
* device instance $19 r0 *1 7.995,2.72 nfet
M$19 \$47 \$125 \$44 vsubs nfet L=0.15U W=1U AS=0.47P AD=0.47P PS=2.94U PD=2.94U
* device instance $20 r0 *1 13.11,2.72 nfet
M$20 \$53 \$127 \$49 vsubs nfet L=0.3U W=1U AS=0.42P AD=0.42P PS=2.84U PD=2.84U
* device instance $21 r0 *1 14.65,2.72 nfet
M$21 \$58 \$128 \$55 vsubs nfet L=0.3U W=1U AS=0.42P AD=0.42P PS=2.84U PD=2.84U
* device instance $22 r0 *1 16.19,2.72 nfet
M$22 \$64 \$61 \$59 vsubs nfet L=0.3U W=1U AS=0.42P AD=0.42P PS=2.84U PD=2.84U
* device instance $23 r0 *1 0.545,4.94 nfet
M$23 \$109 \$108 \$107 vsubs nfet L=0.15U W=1U AS=0.47P AD=0.47P PS=2.94U
+ PD=2.94U
* device instance $24 r0 *1 2.035,4.94 nfet
M$24 \$112 \$111 \$110 vsubs nfet L=0.15U W=1U AS=0.47P AD=0.47P PS=2.94U
+ PD=2.94U
* device instance $25 r0 *1 3.525,4.94 nfet
M$25 \$115 \$114 \$113 vsubs nfet L=0.15U W=1U AS=0.47P AD=0.47P PS=2.94U
+ PD=2.94U
* device instance $26 r0 *1 5.015,4.94 nfet
M$26 \$118 \$117 \$116 vsubs nfet L=0.15U W=1U AS=0.47P AD=0.47P PS=2.94U
+ PD=2.94U
* device instance $27 r0 *1 6.505,4.94 nfet
M$27 \$122 \$120 \$119 vsubs nfet L=0.15U W=1U AS=0.47P AD=0.47P PS=2.94U
+ PD=2.94U
* device instance $28 r0 *1 7.995,4.94 nfet
M$28 \$126 \$124 \$123 vsubs nfet L=0.15U W=1U AS=0.47P AD=0.47P PS=2.94U
+ PD=2.94U
* device instance $29 r0 *1 37.465,5 nfet
M$29 \$130 \$161 \$129 vsubs nfet L=0.15U W=10U AS=4.7P AD=4.7P PS=20.94U
+ PD=20.94U
* device instance $30 r0 *1 42.93,5 nfet
M$30 \$132 \$6 \$131 vsubs nfet L=1U W=10U AS=4.2P AD=4.2P PS=20.84U PD=20.84U
* device instance $31 r0 *1 48.395,1 pfet
M$31 \$76 \$74 \$73 \$183 pfet L=0.15U W=2U AS=0.94P AD=0.94P PS=4.94U PD=4.94U
* device instance $32 r0 *1 49.885,1 pfet
M$32 \$80 \$78 \$77 \$183 pfet L=0.15U W=2U AS=0.94P AD=0.94P PS=4.94U PD=4.94U
* device instance $33 r0 *1 51.375,1 pfet
M$33 \$82 \$7 \$81 \$183 pfet L=0.15U W=2U AS=0.94P AD=0.94P PS=4.94U PD=4.94U
* device instance $34 r0 *1 52.865,1 pfet
M$34 \$85 \$84 \$83 \$183 pfet L=0.15U W=2U AS=0.94P AD=0.94P PS=4.94U PD=4.94U
* device instance $35 r0 *1 54.355,1 pfet
M$35 \$88 \$8 \$86 \$183 pfet L=0.15U W=2U AS=0.94P AD=0.94P PS=4.94U PD=4.94U
* device instance $36 r0 *1 55.845,1 pfet
M$36 \$90 \$9 \$89 \$183 pfet L=0.15U W=2U AS=0.94P AD=0.94P PS=4.94U PD=4.94U
* device instance $37 r0 *1 61.26,1 pfet
M$37 \$93 \$92 \$91 \$159 pfet L=0.3U W=2U AS=0.84P AD=0.84P PS=4.84U PD=4.84U
* device instance $38 r0 *1 62.8,1 pfet
M$38 \$96 \$95 \$94 \$159 pfet L=0.3U W=2U AS=0.84P AD=0.84P PS=4.84U PD=4.84U
* device instance $39 r0 *1 64.34,1 pfet
M$39 \$99 \$10 \$97 \$159 pfet L=0.3U W=2U AS=0.84P AD=0.84P PS=4.84U PD=4.84U
* device instance $40 r0 *1 70.13,1 pfet
M$40 \$101 \$11 \$100 \$106 pfet L=1U W=2U AS=0.84P AD=0.84P PS=4.84U PD=4.84U
* device instance $41 r0 *1 72.37,1 pfet
M$41 \$103 \$12 \$102 \$106 pfet L=1U W=2U AS=0.84P AD=0.84P PS=4.84U PD=4.84U
* device instance $42 r0 *1 78.51,2 pfet
M$42 \$105 \$13 \$104 \$158 pfet L=1U W=4U AS=1.68P AD=1.68P PS=8.84U PD=8.84U
* device instance $43 r0 *1 48.395,4.22 pfet
M$43 \$134 \$75 \$133 \$183 pfet L=0.15U W=2U AS=0.94P AD=0.94P PS=4.94U
+ PD=4.94U
* device instance $44 r0 *1 49.885,4.22 pfet
M$44 \$137 \$79 \$135 \$183 pfet L=0.15U W=2U AS=0.94P AD=0.94P PS=4.94U
+ PD=4.94U
* device instance $45 r0 *1 51.375,4.22 pfet
M$45 \$141 \$139 \$138 \$183 pfet L=0.15U W=2U AS=0.94P AD=0.94P PS=4.94U
+ PD=4.94U
* device instance $46 r0 *1 52.865,4.22 pfet
M$46 \$144 \$143 \$142 \$183 pfet L=0.15U W=2U AS=0.94P AD=0.94P PS=4.94U
+ PD=4.94U
* device instance $47 r0 *1 54.355,4.22 pfet
M$47 \$146 \$87 \$145 \$183 pfet L=0.15U W=2U AS=0.94P AD=0.94P PS=4.94U
+ PD=4.94U
* device instance $48 r0 *1 55.845,4.22 pfet
M$48 \$149 \$148 \$147 \$183 pfet L=0.15U W=2U AS=0.94P AD=0.94P PS=4.94U
+ PD=4.94U
* device instance $49 r0 *1 61.26,4.22 pfet
M$49 \$152 \$151 \$150 \$159 pfet L=0.3U W=2U AS=0.84P AD=0.84P PS=4.84U
+ PD=4.84U
* device instance $50 r0 *1 62.8,4.22 pfet
M$50 \$155 \$154 \$153 \$159 pfet L=0.3U W=2U AS=0.84P AD=0.84P PS=4.84U
+ PD=4.84U
* device instance $51 r0 *1 64.34,4.22 pfet
M$51 \$157 \$98 \$156 \$159 pfet L=0.3U W=2U AS=0.84P AD=0.84P PS=4.84U PD=4.84U
* device instance $52 r0 *1 48.395,7.44 pfet
M$52 \$164 \$163 \$162 \$183 pfet L=0.15U W=2U AS=0.94P AD=0.94P PS=4.94U
+ PD=4.94U
* device instance $53 r0 *1 49.885,7.44 pfet
M$53 \$166 \$136 \$165 \$183 pfet L=0.15U W=2U AS=0.94P AD=0.94P PS=4.94U
+ PD=4.94U
* device instance $54 r0 *1 51.375,7.44 pfet
M$54 \$168 \$140 \$167 \$183 pfet L=0.15U W=2U AS=0.94P AD=0.94P PS=4.94U
+ PD=4.94U
* device instance $55 r0 *1 52.865,7.44 pfet
M$55 \$171 \$170 \$169 \$183 pfet L=0.15U W=2U AS=0.94P AD=0.94P PS=4.94U
+ PD=4.94U
* device instance $56 r0 *1 54.355,7.44 pfet
M$56 \$174 \$173 \$172 \$183 pfet L=0.15U W=2U AS=0.94P AD=0.94P PS=4.94U
+ PD=4.94U
* device instance $57 r0 *1 55.845,7.44 pfet
M$57 \$177 \$176 \$175 \$183 pfet L=0.15U W=2U AS=0.94P AD=0.94P PS=4.94U
+ PD=4.94U
* device instance $58 r0 *1 84.275,10 pfet
M$58 \$179 \$14 \$178 \$184 pfet L=0.15U W=20U AS=9.4P AD=9.4P PS=40.94U
+ PD=40.94U
* device instance $59 r0 *1 90.04,10 pfet
M$59 \$181 \$15 \$180 \$185 pfet L=1U W=20U AS=8.4P AD=8.4P PS=40.84U PD=40.84U
* device instance $60 r0 *1 150.42,25.62 res_xhigh_po
R$60 \$160 \$182 vsubs 600000 res_xhigh_po
.ENDS pll_pfd_cp
