* extracted by klt extract --deck sky130

* cell pll_divider_intN
* pin A
* pin A
* pin A
* pin A
* pin A
* pin A
* pin A
* pin A
* pin A
* pin A
* pin A
* pin A
* pin A
* pin A
* pin A
* pin A
* pin A
* pin A
* pin A
* pin A
* pin A
* pin A
* pin A
* pin A
* pin A
* pin A
* pin A
* pin A
* pin A0
* pin A0
* pin A0
* pin A0
* pin A0
* pin A1
* pin A1
* pin A1
* pin A1
* pin A1
* pin B
* pin B
* pin B
* pin B
* pin B
* pin B
* pin B
* pin B
* pin B
* pin B
* pin B
* pin B
* pin B
* pin B
* pin B
* pin B
* pin B
* pin B
* pin B
* pin B
* pin C
* pin C
* pin C
* pin C
* pin CLK
* pin CLK
* pin CLK
* pin CLK
* pin CLK
* pin CLK
* pin CLK
* pin CLK
* pin CLK
* pin D
* pin D
* pin D
* pin D
* pin D
* pin D
* pin D
* pin D
* pin D
* pin D
* pin D
* pin Q
* pin Q
* pin Q
* pin Q
* pin Q
* pin Q
* pin Q
* pin Q
* pin Q
* pin RESET_B
* pin RESET_B
* pin RESET_B
* pin RESET_B
* pin RESET_B
* pin RESET_B
* pin RESET_B
* pin RESET_B
* pin S
* pin S
* pin S
* pin S
* pin S
* pin VGND
* pin VPB
* pin VPWR
* pin X
* pin X
* pin X
* pin X
* pin X
* pin X
* pin X
* pin X
* pin X
* pin X
* pin X
* pin X
* pin X
* pin X
* pin X
* pin X
* pin X
* pin X
* pin X
* pin X
* pin Y
* pin Y
* pin Y
* pin Y
* pin Y
* pin Y
* pin Y
* pin Y
* pin Y
* pin Y
* pin Y
* pin Y
* pin Y
* pin vsubs
.SUBCKT pll_divider_intN A A$1 A$2 A$3 A$4 A$5 A$6 A$7 A$8 A$9 A$10 A$11 A$12
+ A$13 A$14 A$15 A$16 A$17 A$18 A$19 A$20 A$21 A$22 A$23 A$24 A$25 A$26 A$27 A0
+ A0$1 A0$2 A0$3 A0$4 A1 A1$1 A1$2 A1$3 A1$4 B B$1 B$2 B$3 B$4 B$5 B$6 B$7 B$8
+ B$9 B$10 B$11 B$12 B$13 B$14 B$15 B$16 B$17 B$18 B$19 C C$1 C$2 C$3 CLK CLK$1
+ CLK$2 CLK$3 CLK$4 CLK$5 CLK$6 CLK$7 CLK$8 D D$1 D$2 D$3 D$4 D$5 D$6 D$7 D$8
+ D$9 D$10 Q Q$1 Q$2 Q$3 Q$4 Q$5 Q$6 Q$7 Q$8 RESET_B RESET_B$1 RESET_B$2
+ RESET_B$3 RESET_B$4 RESET_B$5 RESET_B$6 RESET_B$7 S S$1 S$2 S$3 S$4 VGND VPB
+ VPWR X X$1 X$2 X$3 X$4 X$5 X$6 X$7 X$8 X$9 X$10 X$11 X$12 X$13 X$14 X$15 X$16
+ X$17 X$18 X$19 Y Y$1 Y$2 Y$3 Y$4 Y$5 Y$6 Y$7 Y$8 Y$9 Y$10 Y$11 Y$12 vsubs
* device instance $1 r0 *1 0.47,0.445 nfet
M$1 VGND CLK \$87 vsubs nfet L=0.15U W=0.42U AS=0.1092P AD=0.0567P PS=1.36U
+ PD=0.69U
* device instance $2 r0 *1 0.89,0.445 nfet
M$2 \$88 \$87 VGND vsubs nfet L=0.15U W=0.42U AS=0.0567P AD=0.1092P PS=0.69U
+ PD=1.36U
* device instance $3 r0 *1 2.64,0.415 nfet
M$3 \$90 \$87 \$89 vsubs nfet L=0.15U W=0.36U AS=0.066P AD=0.0594P PS=0.745U
+ PD=0.69U
* device instance $4 r0 *1 3.12,0.415 nfet
M$4 \$229 \$88 \$90 vsubs nfet L=0.15U W=0.36U AS=0.0594P AD=0.1401P PS=0.69U
+ PD=1.1U
* device instance $5 r0 *1 5.465,0.415 nfet
M$5 \$92 \$88 \$2 vsubs nfet L=0.15U W=0.36U AS=0.0999P AD=0.0711P PS=0.985U
+ PD=0.755U
* device instance $6 r0 *1 6.01,0.415 nfet
M$6 \$231 \$87 \$92 vsubs nfet L=0.15U W=0.36U AS=0.0711P AD=0.0669P PS=0.755U
+ PD=0.75U
* device instance $7 r0 *1 2.165,0.445 nfet
M$7 \$89 D$2 VGND vsubs nfet L=0.15U W=0.42U AS=0.2205P AD=0.066P PS=1.89U
+ PD=0.745U
* device instance $8 r0 *1 3.95,0.445 nfet
M$8 \$230 \$2 \$229 vsubs nfet L=0.15U W=0.42U AS=0.1401P AD=0.0441P PS=1.1U
+ PD=0.63U
* device instance $9 r0 *1 4.31,0.445 nfet
M$9 VGND RESET_B \$230 vsubs nfet L=0.15U W=0.42U AS=0.0441P AD=0.1346P
+ PS=0.63U PD=1.15U
* device instance $10 r0 *1 6.49,0.445 nfet
M$10 VGND \$3 \$231 vsubs nfet L=0.15U W=0.42U AS=0.0669P AD=0.12495P PS=0.75U
+ PD=1.015U
* device instance $11 r0 *1 7.235,0.445 nfet
M$11 \$232 RESET_B VGND vsubs nfet L=0.15U W=0.42U AS=0.12495P AD=0.06405P
+ PS=1.015U PD=0.725U
* device instance $12 r0 *1 7.69,0.445 nfet
M$12 \$3 \$92 \$232 vsubs nfet L=0.15U W=0.42U AS=0.06405P AD=0.1092P PS=0.725U
+ PD=1.36U
* device instance $13 r0 *1 4.97,0.555 nfet
M$13 \$2 \$90 VGND vsubs nfet L=0.15U W=0.64U AS=0.1346P AD=0.0999P PS=1.15U
+ PD=0.985U
* device instance $14 r0 *1 8.73,0.56 nfet
M$14 Q \$3 VGND vsubs nfet L=0.15U W=0.65U AS=0.2087P AD=0.08775P PS=2.02U
+ PD=0.92U
* device instance $15 r0 *1 9.15,0.56 nfet
M$15 VGND \$3 Q vsubs nfet L=0.15U W=0.65U AS=0.08775P AD=0.169P PS=0.92U
+ PD=1.82U
* device instance $16 r0 *1 11.025,0.445 nfet
M$16 \$233 \$5 VGND vsubs nfet L=0.15U W=0.42U AS=0.097P AD=0.06825P PS=0.975U
+ PD=0.745U
* device instance $17 r0 *1 11.5,0.445 nfet
M$17 \$4 A0 \$233 vsubs nfet L=0.15U W=0.42U AS=0.06825P AD=0.17325P PS=0.745U
+ PD=1.245U
* device instance $18 r0 *1 12.475,0.445 nfet
M$18 \$234 A1 \$4 vsubs nfet L=0.15U W=0.42U AS=0.17325P AD=0.05775P PS=1.245U
+ PD=0.695U
* device instance $19 r0 *1 12.9,0.445 nfet
M$19 VGND S \$234 vsubs nfet L=0.15U W=0.42U AS=0.05775P AD=0.0567P PS=0.695U
+ PD=0.69U
* device instance $20 r0 *1 13.32,0.445 nfet
M$20 \$5 S VGND vsubs nfet L=0.15U W=0.42U AS=0.0567P AD=0.1134P PS=0.69U
+ PD=1.38U
* device instance $21 r0 *1 10.13,0.56 nfet
M$21 X \$4 VGND vsubs nfet L=0.15U W=0.65U AS=0.169P AD=0.08775P PS=1.82U
+ PD=0.92U
* device instance $22 r0 *1 10.55,0.56 nfet
M$22 VGND \$4 X vsubs nfet L=0.15U W=0.65U AS=0.08775P AD=0.097P PS=0.92U
+ PD=0.975U
* device instance $23 r0 *1 14.28,0.56 nfet
M$23 Y A VGND vsubs nfet L=0.15U W=0.65U AS=0.169P AD=0.08775P PS=1.82U PD=0.92U
* device instance $24 r0 *1 14.7,0.56 nfet
M$24 VGND A Y vsubs nfet L=0.15U W=0.65U AS=0.08775P AD=0.169P PS=0.92U PD=1.82U
* device instance $25 r0 *1 15.65,0.445 nfet
M$25 VGND CLK$1 \$97 vsubs nfet L=0.15U W=0.42U AS=0.1092P AD=0.0567P PS=1.36U
+ PD=0.69U
* device instance $26 r0 *1 16.07,0.445 nfet
M$26 \$98 \$97 VGND vsubs nfet L=0.15U W=0.42U AS=0.0567P AD=0.1092P PS=0.69U
+ PD=1.36U
* device instance $27 r0 *1 17.82,0.415 nfet
M$27 \$100 \$97 \$99 vsubs nfet L=0.15U W=0.36U AS=0.066P AD=0.0594P PS=0.745U
+ PD=0.69U
* device instance $28 r0 *1 18.3,0.415 nfet
M$28 \$235 \$98 \$100 vsubs nfet L=0.15U W=0.36U AS=0.0594P AD=0.1401P PS=0.69U
+ PD=1.1U
* device instance $29 r0 *1 20.645,0.415 nfet
M$29 \$102 \$98 \$10 vsubs nfet L=0.15U W=0.36U AS=0.0999P AD=0.0711P PS=0.985U
+ PD=0.755U
* device instance $30 r0 *1 21.19,0.415 nfet
M$30 \$237 \$97 \$102 vsubs nfet L=0.15U W=0.36U AS=0.0711P AD=0.0669P
+ PS=0.755U PD=0.75U
* device instance $31 r0 *1 17.345,0.445 nfet
M$31 \$99 D$3 VGND vsubs nfet L=0.15U W=0.42U AS=0.2205P AD=0.066P PS=1.89U
+ PD=0.745U
* device instance $32 r0 *1 19.13,0.445 nfet
M$32 \$236 \$10 \$235 vsubs nfet L=0.15U W=0.42U AS=0.1401P AD=0.0441P PS=1.1U
+ PD=0.63U
* device instance $33 r0 *1 19.49,0.445 nfet
M$33 VGND RESET_B$1 \$236 vsubs nfet L=0.15U W=0.42U AS=0.0441P AD=0.1346P
+ PS=0.63U PD=1.15U
* device instance $34 r0 *1 21.67,0.445 nfet
M$34 VGND \$11 \$237 vsubs nfet L=0.15U W=0.42U AS=0.0669P AD=0.12495P PS=0.75U
+ PD=1.015U
* device instance $35 r0 *1 22.415,0.445 nfet
M$35 \$238 RESET_B$1 VGND vsubs nfet L=0.15U W=0.42U AS=0.12495P AD=0.06405P
+ PS=1.015U PD=0.725U
* device instance $36 r0 *1 22.87,0.445 nfet
M$36 \$11 \$102 \$238 vsubs nfet L=0.15U W=0.42U AS=0.06405P AD=0.1092P
+ PS=0.725U PD=1.36U
* device instance $37 r0 *1 20.15,0.555 nfet
M$37 \$10 \$100 VGND vsubs nfet L=0.15U W=0.64U AS=0.1346P AD=0.0999P PS=1.15U
+ PD=0.985U
* device instance $38 r0 *1 23.91,0.56 nfet
M$38 Q$1 \$11 VGND vsubs nfet L=0.15U W=0.65U AS=0.2087P AD=0.08775P PS=2.02U
+ PD=0.92U
* device instance $39 r0 *1 24.33,0.56 nfet
M$39 VGND \$11 Q$1 vsubs nfet L=0.15U W=0.65U AS=0.08775P AD=0.169P PS=0.92U
+ PD=1.82U
* device instance $40 r0 *1 26.205,0.445 nfet
M$40 \$239 \$13 VGND vsubs nfet L=0.15U W=0.42U AS=0.097P AD=0.06825P PS=0.975U
+ PD=0.745U
* device instance $41 r0 *1 26.68,0.445 nfet
M$41 \$12 A0$1 \$239 vsubs nfet L=0.15U W=0.42U AS=0.06825P AD=0.17325P
+ PS=0.745U PD=1.245U
* device instance $42 r0 *1 27.655,0.445 nfet
M$42 \$240 A1$1 \$12 vsubs nfet L=0.15U W=0.42U AS=0.17325P AD=0.05775P
+ PS=1.245U PD=0.695U
* device instance $43 r0 *1 28.08,0.445 nfet
M$43 VGND S$1 \$240 vsubs nfet L=0.15U W=0.42U AS=0.05775P AD=0.0567P PS=0.695U
+ PD=0.69U
* device instance $44 r0 *1 28.5,0.445 nfet
M$44 \$13 S$1 VGND vsubs nfet L=0.15U W=0.42U AS=0.0567P AD=0.1134P PS=0.69U
+ PD=1.38U
* device instance $45 r0 *1 25.31,0.56 nfet
M$45 X$1 \$12 VGND vsubs nfet L=0.15U W=0.65U AS=0.169P AD=0.08775P PS=1.82U
+ PD=0.92U
* device instance $46 r0 *1 25.73,0.56 nfet
M$46 VGND \$12 X$1 vsubs nfet L=0.15U W=0.65U AS=0.08775P AD=0.097P PS=0.92U
+ PD=0.975U
* device instance $47 r0 *1 29.465,0.56 nfet
M$47 \$105 A$1 VGND vsubs nfet L=0.15U W=0.65U AS=0.17875P AD=0.08775P PS=1.85U
+ PD=0.92U
* device instance $48 r0 *1 29.885,0.56 nfet
M$48 VGND A$1 \$105 vsubs nfet L=0.15U W=0.65U AS=0.08775P AD=0.08775P PS=0.92U
+ PD=0.92U
* device instance $49 r0 *1 30.305,0.56 nfet
M$49 \$105 B VGND vsubs nfet L=0.15U W=0.65U AS=0.08775P AD=0.08775P PS=0.92U
+ PD=0.92U
* device instance $50 r0 *1 30.725,0.56 nfet
M$50 VGND B \$105 vsubs nfet L=0.15U W=0.65U AS=0.08775P AD=0.169P PS=0.92U
+ PD=1.82U
* device instance $51 r0 *1 31.665,0.56 nfet
M$51 VGND A$1 \$106 vsubs nfet L=0.15U W=0.65U AS=0.169P AD=0.08775P PS=1.82U
+ PD=0.92U
* device instance $52 r0 *1 32.085,0.56 nfet
M$52 \$106 A$1 VGND vsubs nfet L=0.15U W=0.65U AS=0.08775P AD=0.08775P PS=0.92U
+ PD=0.92U
* device instance $53 r0 *1 32.505,0.56 nfet
M$53 X$2 B \$106 vsubs nfet L=0.15U W=0.65U AS=0.08775P AD=0.105625P PS=0.92U
+ PD=0.975U
* device instance $54 r0 *1 32.98,0.56 nfet
M$54 \$106 B X$2 vsubs nfet L=0.15U W=0.65U AS=0.105625P AD=0.169P PS=0.975U
+ PD=1.82U
* device instance $55 r0 *1 33.92,0.56 nfet
M$55 X$2 \$105 VGND vsubs nfet L=0.15U W=0.65U AS=0.169P AD=0.08775P PS=1.82U
+ PD=0.92U
* device instance $56 r0 *1 34.34,0.56 nfet
M$56 VGND \$105 X$2 vsubs nfet L=0.15U W=0.65U AS=0.08775P AD=0.169P PS=0.92U
+ PD=1.82U
* device instance $57 r0 *1 35.44,0.56 nfet
M$57 Y$1 A$2 VGND vsubs nfet L=0.15U W=0.65U AS=0.169P AD=0.08775P PS=1.82U
+ PD=0.92U
* device instance $58 r0 *1 35.86,0.56 nfet
M$58 VGND A$2 Y$1 vsubs nfet L=0.15U W=0.65U AS=0.08775P AD=0.169P PS=0.92U
+ PD=1.82U
* device instance $59 r0 *1 36.81,0.445 nfet
M$59 VGND CLK$2 \$110 vsubs nfet L=0.15U W=0.42U AS=0.1092P AD=0.0567P PS=1.36U
+ PD=0.69U
* device instance $60 r0 *1 37.23,0.445 nfet
M$60 \$111 \$110 VGND vsubs nfet L=0.15U W=0.42U AS=0.0567P AD=0.1092P PS=0.69U
+ PD=1.36U
* device instance $61 r0 *1 38.98,0.415 nfet
M$61 \$113 \$110 \$112 vsubs nfet L=0.15U W=0.36U AS=0.066P AD=0.0594P
+ PS=0.745U PD=0.69U
* device instance $62 r0 *1 39.46,0.415 nfet
M$62 \$241 \$111 \$113 vsubs nfet L=0.15U W=0.36U AS=0.0594P AD=0.1401P
+ PS=0.69U PD=1.1U
* device instance $63 r0 *1 41.805,0.415 nfet
M$63 \$115 \$111 \$20 vsubs nfet L=0.15U W=0.36U AS=0.0999P AD=0.0711P
+ PS=0.985U PD=0.755U
* device instance $64 r0 *1 42.35,0.415 nfet
M$64 \$243 \$110 \$115 vsubs nfet L=0.15U W=0.36U AS=0.0711P AD=0.0669P
+ PS=0.755U PD=0.75U
* device instance $65 r0 *1 38.505,0.445 nfet
M$65 \$112 D$4 VGND vsubs nfet L=0.15U W=0.42U AS=0.2205P AD=0.066P PS=1.89U
+ PD=0.745U
* device instance $66 r0 *1 40.29,0.445 nfet
M$66 \$242 \$20 \$241 vsubs nfet L=0.15U W=0.42U AS=0.1401P AD=0.0441P PS=1.1U
+ PD=0.63U
* device instance $67 r0 *1 40.65,0.445 nfet
M$67 VGND RESET_B$2 \$242 vsubs nfet L=0.15U W=0.42U AS=0.0441P AD=0.1346P
+ PS=0.63U PD=1.15U
* device instance $68 r0 *1 42.83,0.445 nfet
M$68 VGND \$21 \$243 vsubs nfet L=0.15U W=0.42U AS=0.0669P AD=0.12495P PS=0.75U
+ PD=1.015U
* device instance $69 r0 *1 43.575,0.445 nfet
M$69 \$244 RESET_B$2 VGND vsubs nfet L=0.15U W=0.42U AS=0.12495P AD=0.06405P
+ PS=1.015U PD=0.725U
* device instance $70 r0 *1 44.03,0.445 nfet
M$70 \$21 \$115 \$244 vsubs nfet L=0.15U W=0.42U AS=0.06405P AD=0.1092P
+ PS=0.725U PD=1.36U
* device instance $71 r0 *1 41.31,0.555 nfet
M$71 \$20 \$113 VGND vsubs nfet L=0.15U W=0.64U AS=0.1346P AD=0.0999P PS=1.15U
+ PD=0.985U
* device instance $72 r0 *1 45.07,0.56 nfet
M$72 Q$2 \$21 VGND vsubs nfet L=0.15U W=0.65U AS=0.2087P AD=0.08775P PS=2.02U
+ PD=0.92U
* device instance $73 r0 *1 45.49,0.56 nfet
M$73 VGND \$21 Q$2 vsubs nfet L=0.15U W=0.65U AS=0.08775P AD=0.169P PS=0.92U
+ PD=1.82U
* device instance $74 r0 *1 47.365,0.445 nfet
M$74 \$245 \$23 VGND vsubs nfet L=0.15U W=0.42U AS=0.097P AD=0.06825P PS=0.975U
+ PD=0.745U
* device instance $75 r0 *1 47.84,0.445 nfet
M$75 \$22 A0$2 \$245 vsubs nfet L=0.15U W=0.42U AS=0.06825P AD=0.17325P
+ PS=0.745U PD=1.245U
* device instance $76 r0 *1 48.815,0.445 nfet
M$76 \$246 A1$2 \$22 vsubs nfet L=0.15U W=0.42U AS=0.17325P AD=0.05775P
+ PS=1.245U PD=0.695U
* device instance $77 r0 *1 49.24,0.445 nfet
M$77 VGND S$2 \$246 vsubs nfet L=0.15U W=0.42U AS=0.05775P AD=0.0567P PS=0.695U
+ PD=0.69U
* device instance $78 r0 *1 49.66,0.445 nfet
M$78 \$23 S$2 VGND vsubs nfet L=0.15U W=0.42U AS=0.0567P AD=0.1134P PS=0.69U
+ PD=1.38U
* device instance $79 r0 *1 46.47,0.56 nfet
M$79 X$3 \$22 VGND vsubs nfet L=0.15U W=0.65U AS=0.169P AD=0.08775P PS=1.82U
+ PD=0.92U
* device instance $80 r0 *1 46.89,0.56 nfet
M$80 VGND \$22 X$3 vsubs nfet L=0.15U W=0.65U AS=0.08775P AD=0.097P PS=0.92U
+ PD=0.975U
* device instance $81 r0 *1 50.625,0.56 nfet
M$81 \$118 A$3 VGND vsubs nfet L=0.15U W=0.65U AS=0.17875P AD=0.08775P PS=1.85U
+ PD=0.92U
* device instance $82 r0 *1 51.045,0.56 nfet
M$82 VGND A$3 \$118 vsubs nfet L=0.15U W=0.65U AS=0.08775P AD=0.08775P PS=0.92U
+ PD=0.92U
* device instance $83 r0 *1 51.465,0.56 nfet
M$83 \$118 B$1 VGND vsubs nfet L=0.15U W=0.65U AS=0.08775P AD=0.08775P PS=0.92U
+ PD=0.92U
* device instance $84 r0 *1 51.885,0.56 nfet
M$84 VGND B$1 \$118 vsubs nfet L=0.15U W=0.65U AS=0.08775P AD=0.169P PS=0.92U
+ PD=1.82U
* device instance $85 r0 *1 52.825,0.56 nfet
M$85 VGND A$3 \$119 vsubs nfet L=0.15U W=0.65U AS=0.169P AD=0.08775P PS=1.82U
+ PD=0.92U
* device instance $86 r0 *1 53.245,0.56 nfet
M$86 \$119 A$3 VGND vsubs nfet L=0.15U W=0.65U AS=0.08775P AD=0.08775P PS=0.92U
+ PD=0.92U
* device instance $87 r0 *1 53.665,0.56 nfet
M$87 X$4 B$1 \$119 vsubs nfet L=0.15U W=0.65U AS=0.08775P AD=0.105625P PS=0.92U
+ PD=0.975U
* device instance $88 r0 *1 54.14,0.56 nfet
M$88 \$119 B$1 X$4 vsubs nfet L=0.15U W=0.65U AS=0.105625P AD=0.169P PS=0.975U
+ PD=1.82U
* device instance $89 r0 *1 55.08,0.56 nfet
M$89 X$4 \$118 VGND vsubs nfet L=0.15U W=0.65U AS=0.169P AD=0.08775P PS=1.82U
+ PD=0.92U
* device instance $90 r0 *1 55.5,0.56 nfet
M$90 VGND \$118 X$4 vsubs nfet L=0.15U W=0.65U AS=0.08775P AD=0.169P PS=0.92U
+ PD=1.82U
* device instance $91 r0 *1 56.78,0.585 nfet
M$91 \$247 A$22 \$121 vsubs nfet L=0.15U W=0.42U AS=0.1176P AD=0.0567P PS=1.4U
+ PD=0.69U
* device instance $92 r0 *1 57.2,0.585 nfet
M$92 \$247 B$14 VGND vsubs nfet L=0.15U W=0.42U AS=0.1118P AD=0.0567P PS=1.04U
+ PD=0.69U
* device instance $93 r0 *1 57.74,0.56 nfet
M$93 X$5 \$121 VGND vsubs nfet L=0.15U W=0.65U AS=0.1118P AD=0.12675P PS=1.04U
+ PD=1.04U
* device instance $94 r0 *1 58.28,0.56 nfet
M$94 VGND \$121 X$5 vsubs nfet L=0.15U W=0.65U AS=0.12675P AD=0.247P PS=1.04U
+ PD=2.06U
* device instance $95 r0 *1 59.36,0.56 nfet
M$95 Y$2 A$4 VGND vsubs nfet L=0.15U W=0.65U AS=0.169P AD=0.08775P PS=1.82U
+ PD=0.92U
* device instance $96 r0 *1 59.78,0.56 nfet
M$96 VGND A$4 Y$2 vsubs nfet L=0.15U W=0.65U AS=0.08775P AD=0.169P PS=0.92U
+ PD=1.82U
* device instance $97 r0 *1 60.73,0.445 nfet
M$97 VGND CLK$3 \$127 vsubs nfet L=0.15U W=0.42U AS=0.1092P AD=0.0567P PS=1.36U
+ PD=0.69U
* device instance $98 r0 *1 61.15,0.445 nfet
M$98 \$128 \$127 VGND vsubs nfet L=0.15U W=0.42U AS=0.0567P AD=0.1092P PS=0.69U
+ PD=1.36U
* device instance $99 r0 *1 62.9,0.415 nfet
M$99 \$130 \$127 \$129 vsubs nfet L=0.15U W=0.36U AS=0.066P AD=0.0594P
+ PS=0.745U PD=0.69U
* device instance $100 r0 *1 63.38,0.415 nfet
M$100 \$248 \$128 \$130 vsubs nfet L=0.15U W=0.36U AS=0.0594P AD=0.1401P
+ PS=0.69U PD=1.1U
* device instance $101 r0 *1 65.725,0.415 nfet
M$101 \$132 \$128 \$30 vsubs nfet L=0.15U W=0.36U AS=0.0999P AD=0.0711P
+ PS=0.985U PD=0.755U
* device instance $102 r0 *1 66.27,0.415 nfet
M$102 \$251 \$127 \$132 vsubs nfet L=0.15U W=0.36U AS=0.0711P AD=0.0669P
+ PS=0.755U PD=0.75U
* device instance $103 r0 *1 62.425,0.445 nfet
M$103 \$129 D$5 VGND vsubs nfet L=0.15U W=0.42U AS=0.2205P AD=0.066P PS=1.89U
+ PD=0.745U
* device instance $104 r0 *1 64.21,0.445 nfet
M$104 \$249 \$30 \$248 vsubs nfet L=0.15U W=0.42U AS=0.1401P AD=0.0441P PS=1.1U
+ PD=0.63U
* device instance $105 r0 *1 64.57,0.445 nfet
M$105 VGND RESET_B$3 \$249 vsubs nfet L=0.15U W=0.42U AS=0.0441P AD=0.1346P
+ PS=0.63U PD=1.15U
* device instance $106 r0 *1 66.75,0.445 nfet
M$106 VGND \$31 \$251 vsubs nfet L=0.15U W=0.42U AS=0.0669P AD=0.12495P
+ PS=0.75U PD=1.015U
* device instance $107 r0 *1 67.495,0.445 nfet
M$107 \$252 RESET_B$3 VGND vsubs nfet L=0.15U W=0.42U AS=0.12495P AD=0.06405P
+ PS=1.015U PD=0.725U
* device instance $108 r0 *1 67.95,0.445 nfet
M$108 \$31 \$132 \$252 vsubs nfet L=0.15U W=0.42U AS=0.06405P AD=0.1092P
+ PS=0.725U PD=1.36U
* device instance $109 r0 *1 65.23,0.555 nfet
M$109 \$30 \$130 VGND vsubs nfet L=0.15U W=0.64U AS=0.1346P AD=0.0999P PS=1.15U
+ PD=0.985U
* device instance $110 r0 *1 68.99,0.56 nfet
M$110 Q$3 \$31 VGND vsubs nfet L=0.15U W=0.65U AS=0.2087P AD=0.08775P PS=2.02U
+ PD=0.92U
* device instance $111 r0 *1 69.41,0.56 nfet
M$111 VGND \$31 Q$3 vsubs nfet L=0.15U W=0.65U AS=0.08775P AD=0.169P PS=0.92U
+ PD=1.82U
* device instance $112 r0 *1 71.285,0.445 nfet
M$112 \$253 \$33 VGND vsubs nfet L=0.15U W=0.42U AS=0.097P AD=0.06825P
+ PS=0.975U PD=0.745U
* device instance $113 r0 *1 71.76,0.445 nfet
M$113 \$32 A0$3 \$253 vsubs nfet L=0.15U W=0.42U AS=0.06825P AD=0.17325P
+ PS=0.745U PD=1.245U
* device instance $114 r0 *1 72.735,0.445 nfet
M$114 \$254 A1$3 \$32 vsubs nfet L=0.15U W=0.42U AS=0.17325P AD=0.05775P
+ PS=1.245U PD=0.695U
* device instance $115 r0 *1 73.16,0.445 nfet
M$115 VGND S$3 \$254 vsubs nfet L=0.15U W=0.42U AS=0.05775P AD=0.0567P
+ PS=0.695U PD=0.69U
* device instance $116 r0 *1 73.58,0.445 nfet
M$116 \$33 S$3 VGND vsubs nfet L=0.15U W=0.42U AS=0.0567P AD=0.1134P PS=0.69U
+ PD=1.38U
* device instance $117 r0 *1 70.39,0.56 nfet
M$117 X$6 \$32 VGND vsubs nfet L=0.15U W=0.65U AS=0.169P AD=0.08775P PS=1.82U
+ PD=0.92U
* device instance $118 r0 *1 70.81,0.56 nfet
M$118 VGND \$32 X$6 vsubs nfet L=0.15U W=0.65U AS=0.08775P AD=0.097P PS=0.92U
+ PD=0.975U
* device instance $119 r0 *1 74.545,0.56 nfet
M$119 \$135 A$5 VGND vsubs nfet L=0.15U W=0.65U AS=0.17875P AD=0.08775P
+ PS=1.85U PD=0.92U
* device instance $120 r0 *1 74.965,0.56 nfet
M$120 VGND A$5 \$135 vsubs nfet L=0.15U W=0.65U AS=0.08775P AD=0.08775P
+ PS=0.92U PD=0.92U
* device instance $121 r0 *1 75.385,0.56 nfet
M$121 \$135 B$2 VGND vsubs nfet L=0.15U W=0.65U AS=0.08775P AD=0.08775P
+ PS=0.92U PD=0.92U
* device instance $122 r0 *1 75.805,0.56 nfet
M$122 VGND B$2 \$135 vsubs nfet L=0.15U W=0.65U AS=0.08775P AD=0.169P PS=0.92U
+ PD=1.82U
* device instance $123 r0 *1 76.745,0.56 nfet
M$123 VGND A$5 \$136 vsubs nfet L=0.15U W=0.65U AS=0.169P AD=0.08775P PS=1.82U
+ PD=0.92U
* device instance $124 r0 *1 77.165,0.56 nfet
M$124 \$136 A$5 VGND vsubs nfet L=0.15U W=0.65U AS=0.08775P AD=0.08775P
+ PS=0.92U PD=0.92U
* device instance $125 r0 *1 77.585,0.56 nfet
M$125 X$7 B$2 \$136 vsubs nfet L=0.15U W=0.65U AS=0.08775P AD=0.105625P
+ PS=0.92U PD=0.975U
* device instance $126 r0 *1 78.06,0.56 nfet
M$126 \$136 B$2 X$7 vsubs nfet L=0.15U W=0.65U AS=0.105625P AD=0.169P PS=0.975U
+ PD=1.82U
* device instance $127 r0 *1 79,0.56 nfet
M$127 X$7 \$135 VGND vsubs nfet L=0.15U W=0.65U AS=0.169P AD=0.08775P PS=1.82U
+ PD=0.92U
* device instance $128 r0 *1 79.42,0.56 nfet
M$128 VGND \$135 X$7 vsubs nfet L=0.15U W=0.65U AS=0.08775P AD=0.169P PS=0.92U
+ PD=1.82U
* device instance $129 r0 *1 83.28,0.56 nfet
M$129 Y$3 A$6 VGND vsubs nfet L=0.15U W=0.65U AS=0.169P AD=0.08775P PS=1.82U
+ PD=0.92U
* device instance $130 r0 *1 83.7,0.56 nfet
M$130 VGND A$6 Y$3 vsubs nfet L=0.15U W=0.65U AS=0.08775P AD=0.169P PS=0.92U
+ PD=1.82U
* device instance $131 r0 *1 84.65,0.445 nfet
M$131 VGND CLK$4 \$145 vsubs nfet L=0.15U W=0.42U AS=0.1092P AD=0.0567P
+ PS=1.36U PD=0.69U
* device instance $132 r0 *1 85.07,0.445 nfet
M$132 \$146 \$145 VGND vsubs nfet L=0.15U W=0.42U AS=0.0567P AD=0.1092P
+ PS=0.69U PD=1.36U
* device instance $133 r0 *1 86.82,0.415 nfet
M$133 \$148 \$145 \$147 vsubs nfet L=0.15U W=0.36U AS=0.066P AD=0.0594P
+ PS=0.745U PD=0.69U
* device instance $134 r0 *1 87.3,0.415 nfet
M$134 \$257 \$146 \$148 vsubs nfet L=0.15U W=0.36U AS=0.0594P AD=0.1401P
+ PS=0.69U PD=1.1U
* device instance $135 r0 *1 89.645,0.415 nfet
M$135 \$150 \$146 \$40 vsubs nfet L=0.15U W=0.36U AS=0.0999P AD=0.0711P
+ PS=0.985U PD=0.755U
* device instance $136 r0 *1 90.19,0.415 nfet
M$136 \$259 \$145 \$150 vsubs nfet L=0.15U W=0.36U AS=0.0711P AD=0.0669P
+ PS=0.755U PD=0.75U
* device instance $137 r0 *1 86.345,0.445 nfet
M$137 \$147 D$6 VGND vsubs nfet L=0.15U W=0.42U AS=0.2205P AD=0.066P PS=1.89U
+ PD=0.745U
* device instance $138 r0 *1 88.13,0.445 nfet
M$138 \$258 \$40 \$257 vsubs nfet L=0.15U W=0.42U AS=0.1401P AD=0.0441P PS=1.1U
+ PD=0.63U
* device instance $139 r0 *1 88.49,0.445 nfet
M$139 VGND RESET_B$4 \$258 vsubs nfet L=0.15U W=0.42U AS=0.0441P AD=0.1346P
+ PS=0.63U PD=1.15U
* device instance $140 r0 *1 90.67,0.445 nfet
M$140 VGND \$41 \$259 vsubs nfet L=0.15U W=0.42U AS=0.0669P AD=0.12495P
+ PS=0.75U PD=1.015U
* device instance $141 r0 *1 91.415,0.445 nfet
M$141 \$260 RESET_B$4 VGND vsubs nfet L=0.15U W=0.42U AS=0.12495P AD=0.06405P
+ PS=1.015U PD=0.725U
* device instance $142 r0 *1 91.87,0.445 nfet
M$142 \$41 \$150 \$260 vsubs nfet L=0.15U W=0.42U AS=0.06405P AD=0.1092P
+ PS=0.725U PD=1.36U
* device instance $143 r0 *1 89.15,0.555 nfet
M$143 \$40 \$148 VGND vsubs nfet L=0.15U W=0.64U AS=0.1346P AD=0.0999P PS=1.15U
+ PD=0.985U
* device instance $144 r0 *1 92.91,0.56 nfet
M$144 Q$4 \$41 VGND vsubs nfet L=0.15U W=0.65U AS=0.2087P AD=0.08775P PS=2.02U
+ PD=0.92U
* device instance $145 r0 *1 93.33,0.56 nfet
M$145 VGND \$41 Q$4 vsubs nfet L=0.15U W=0.65U AS=0.08775P AD=0.169P PS=0.92U
+ PD=1.82U
* device instance $146 r0 *1 95.205,0.445 nfet
M$146 \$261 \$43 VGND vsubs nfet L=0.15U W=0.42U AS=0.097P AD=0.06825P
+ PS=0.975U PD=0.745U
* device instance $147 r0 *1 95.68,0.445 nfet
M$147 \$42 A0$4 \$261 vsubs nfet L=0.15U W=0.42U AS=0.06825P AD=0.17325P
+ PS=0.745U PD=1.245U
* device instance $148 r0 *1 96.655,0.445 nfet
M$148 \$262 A1$4 \$42 vsubs nfet L=0.15U W=0.42U AS=0.17325P AD=0.05775P
+ PS=1.245U PD=0.695U
* device instance $149 r0 *1 97.08,0.445 nfet
M$149 VGND S$4 \$262 vsubs nfet L=0.15U W=0.42U AS=0.05775P AD=0.0567P
+ PS=0.695U PD=0.69U
* device instance $150 r0 *1 97.5,0.445 nfet
M$150 \$43 S$4 VGND vsubs nfet L=0.15U W=0.42U AS=0.0567P AD=0.1134P PS=0.69U
+ PD=1.38U
* device instance $151 r0 *1 94.31,0.56 nfet
M$151 X$9 \$42 VGND vsubs nfet L=0.15U W=0.65U AS=0.169P AD=0.08775P PS=1.82U
+ PD=0.92U
* device instance $152 r0 *1 94.73,0.56 nfet
M$152 VGND \$42 X$9 vsubs nfet L=0.15U W=0.65U AS=0.08775P AD=0.097P PS=0.92U
+ PD=0.975U
* device instance $153 r0 *1 98.465,0.56 nfet
M$153 \$153 A$7 VGND vsubs nfet L=0.15U W=0.65U AS=0.17875P AD=0.08775P
+ PS=1.85U PD=0.92U
* device instance $154 r0 *1 98.885,0.56 nfet
M$154 VGND A$7 \$153 vsubs nfet L=0.15U W=0.65U AS=0.08775P AD=0.08775P
+ PS=0.92U PD=0.92U
* device instance $155 r0 *1 99.305,0.56 nfet
M$155 \$153 B$3 VGND vsubs nfet L=0.15U W=0.65U AS=0.08775P AD=0.08775P
+ PS=0.92U PD=0.92U
* device instance $156 r0 *1 99.725,0.56 nfet
M$156 VGND B$3 \$153 vsubs nfet L=0.15U W=0.65U AS=0.08775P AD=0.169P PS=0.92U
+ PD=1.82U
* device instance $157 r0 *1 100.665,0.56 nfet
M$157 VGND A$7 \$154 vsubs nfet L=0.15U W=0.65U AS=0.169P AD=0.08775P PS=1.82U
+ PD=0.92U
* device instance $158 r0 *1 101.085,0.56 nfet
M$158 \$154 A$7 VGND vsubs nfet L=0.15U W=0.65U AS=0.08775P AD=0.08775P
+ PS=0.92U PD=0.92U
* device instance $159 r0 *1 101.505,0.56 nfet
M$159 X$10 B$3 \$154 vsubs nfet L=0.15U W=0.65U AS=0.08775P AD=0.105625P
+ PS=0.92U PD=0.975U
* device instance $160 r0 *1 101.98,0.56 nfet
M$160 \$154 B$3 X$10 vsubs nfet L=0.15U W=0.65U AS=0.105625P AD=0.169P
+ PS=0.975U PD=1.82U
* device instance $161 r0 *1 102.92,0.56 nfet
M$161 X$10 \$153 VGND vsubs nfet L=0.15U W=0.65U AS=0.169P AD=0.08775P PS=1.82U
+ PD=0.92U
* device instance $162 r0 *1 103.34,0.56 nfet
M$162 VGND \$153 X$10 vsubs nfet L=0.15U W=0.65U AS=0.08775P AD=0.169P PS=0.92U
+ PD=1.82U
* device instance $163 r0 *1 104.43,0.445 nfet
M$163 \$263 A$8 \$53 vsubs nfet L=0.15U W=0.42U AS=0.1092P AD=0.06195P PS=1.36U
+ PD=0.715U
* device instance $164 r0 *1 104.875,0.445 nfet
M$164 \$265 B$4 \$263 vsubs nfet L=0.15U W=0.42U AS=0.06195P AD=0.0798P
+ PS=0.715U PD=0.8U
* device instance $165 r0 *1 105.405,0.445 nfet
M$165 \$266 C \$265 vsubs nfet L=0.15U W=0.42U AS=0.0798P AD=0.0693P PS=0.8U
+ PD=0.75U
* device instance $166 r0 *1 105.885,0.445 nfet
M$166 VGND D \$266 vsubs nfet L=0.15U W=0.42U AS=0.0693P AD=0.17515P PS=0.75U
+ PD=1.265U
* device instance $167 r0 *1 106.65,0.56 nfet
M$167 X$11 \$53 VGND vsubs nfet L=0.15U W=0.65U AS=0.17515P AD=0.10725P
+ PS=1.265U PD=0.98U
* device instance $168 r0 *1 107.13,0.56 nfet
M$168 VGND \$53 X$11 vsubs nfet L=0.15U W=0.65U AS=0.10725P AD=0.195P PS=0.98U
+ PD=1.9U
* device instance $169 r0 *1 108.12,0.56 nfet
M$169 Y$4 A$9 VGND vsubs nfet L=0.15U W=0.65U AS=0.169P AD=0.08775P PS=1.82U
+ PD=0.92U
* device instance $170 r0 *1 108.54,0.56 nfet
M$170 VGND A$9 Y$4 vsubs nfet L=0.15U W=0.65U AS=0.08775P AD=0.169P PS=0.92U
+ PD=1.82U
* device instance $171 r0 *1 109.68,0.585 nfet
M$171 \$268 A$24 \$158 vsubs nfet L=0.15U W=0.42U AS=0.1176P AD=0.0567P PS=1.4U
+ PD=0.69U
* device instance $172 r0 *1 110.1,0.585 nfet
M$172 \$268 B$16 VGND vsubs nfet L=0.15U W=0.42U AS=0.1118P AD=0.0567P PS=1.04U
+ PD=0.69U
* device instance $173 r0 *1 110.64,0.56 nfet
M$173 X$12 \$158 VGND vsubs nfet L=0.15U W=0.65U AS=0.1118P AD=0.12675P
+ PS=1.04U PD=1.04U
* device instance $174 r0 *1 111.18,0.56 nfet
M$174 VGND \$158 X$12 vsubs nfet L=0.15U W=0.65U AS=0.12675P AD=0.247P PS=1.04U
+ PD=2.06U
* device instance $175 r0 *1 112.25,0.445 nfet
M$175 VGND CLK$5 \$163 vsubs nfet L=0.15U W=0.42U AS=0.1092P AD=0.0567P
+ PS=1.36U PD=0.69U
* device instance $176 r0 *1 112.67,0.445 nfet
M$176 \$164 \$163 VGND vsubs nfet L=0.15U W=0.42U AS=0.0567P AD=0.1092P
+ PS=0.69U PD=1.36U
* device instance $177 r0 *1 114.42,0.415 nfet
M$177 \$166 \$163 \$165 vsubs nfet L=0.15U W=0.36U AS=0.066P AD=0.0594P
+ PS=0.745U PD=0.69U
* device instance $178 r0 *1 114.9,0.415 nfet
M$178 \$269 \$164 \$166 vsubs nfet L=0.15U W=0.36U AS=0.0594P AD=0.1401P
+ PS=0.69U PD=1.1U
* device instance $179 r0 *1 117.245,0.415 nfet
M$179 \$168 \$164 \$55 vsubs nfet L=0.15U W=0.36U AS=0.0999P AD=0.0711P
+ PS=0.985U PD=0.755U
* device instance $180 r0 *1 117.79,0.415 nfet
M$180 \$272 \$163 \$168 vsubs nfet L=0.15U W=0.36U AS=0.0711P AD=0.0669P
+ PS=0.755U PD=0.75U
* device instance $181 r0 *1 113.945,0.445 nfet
M$181 \$165 D$7 VGND vsubs nfet L=0.15U W=0.42U AS=0.2205P AD=0.066P PS=1.89U
+ PD=0.745U
* device instance $182 r0 *1 115.73,0.445 nfet
M$182 \$271 \$55 \$269 vsubs nfet L=0.15U W=0.42U AS=0.1401P AD=0.0441P PS=1.1U
+ PD=0.63U
* device instance $183 r0 *1 116.09,0.445 nfet
M$183 VGND RESET_B$5 \$271 vsubs nfet L=0.15U W=0.42U AS=0.0441P AD=0.1346P
+ PS=0.63U PD=1.15U
* device instance $184 r0 *1 118.27,0.445 nfet
M$184 VGND \$56 \$272 vsubs nfet L=0.15U W=0.42U AS=0.0669P AD=0.12495P
+ PS=0.75U PD=1.015U
* device instance $185 r0 *1 119.015,0.445 nfet
M$185 \$273 RESET_B$5 VGND vsubs nfet L=0.15U W=0.42U AS=0.12495P AD=0.06405P
+ PS=1.015U PD=0.725U
* device instance $186 r0 *1 119.47,0.445 nfet
M$186 \$56 \$168 \$273 vsubs nfet L=0.15U W=0.42U AS=0.06405P AD=0.1092P
+ PS=0.725U PD=1.36U
* device instance $187 r0 *1 116.75,0.555 nfet
M$187 \$55 \$166 VGND vsubs nfet L=0.15U W=0.64U AS=0.1346P AD=0.0999P PS=1.15U
+ PD=0.985U
* device instance $188 r0 *1 120.51,0.56 nfet
M$188 Q$5 \$56 VGND vsubs nfet L=0.15U W=0.65U AS=0.2087P AD=0.08775P PS=2.02U
+ PD=0.92U
* device instance $189 r0 *1 120.93,0.56 nfet
M$189 VGND \$56 Q$5 vsubs nfet L=0.15U W=0.65U AS=0.08775P AD=0.169P PS=0.92U
+ PD=1.82U
* device instance $190 r0 *1 121.93,0.56 nfet
M$190 Y$5 A$10 VGND vsubs nfet L=0.15U W=0.65U AS=0.182P AD=0.08775P PS=1.86U
+ PD=0.92U
* device instance $191 r0 *1 122.35,0.56 nfet
M$191 VGND A$10 Y$5 vsubs nfet L=0.15U W=0.65U AS=0.08775P AD=0.08775P PS=0.92U
+ PD=0.92U
* device instance $192 r0 *1 122.77,0.56 nfet
M$192 Y$5 B$5 VGND vsubs nfet L=0.15U W=0.65U AS=0.08775P AD=0.08775P PS=0.92U
+ PD=0.92U
* device instance $193 r0 *1 123.19,0.56 nfet
M$193 VGND B$5 Y$5 vsubs nfet L=0.15U W=0.65U AS=0.08775P AD=0.169P PS=0.92U
+ PD=1.82U
* device instance $194 r0 *1 124.21,0.445 nfet
M$194 VGND CLK$6 \$172 vsubs nfet L=0.15U W=0.42U AS=0.1092P AD=0.0567P
+ PS=1.36U PD=0.69U
* device instance $195 r0 *1 124.63,0.445 nfet
M$195 \$173 \$172 VGND vsubs nfet L=0.15U W=0.42U AS=0.0567P AD=0.1092P
+ PS=0.69U PD=1.36U
* device instance $196 r0 *1 126.38,0.415 nfet
M$196 \$175 \$172 \$174 vsubs nfet L=0.15U W=0.36U AS=0.066P AD=0.0594P
+ PS=0.745U PD=0.69U
* device instance $197 r0 *1 126.86,0.415 nfet
M$197 \$276 \$173 \$175 vsubs nfet L=0.15U W=0.36U AS=0.0594P AD=0.1401P
+ PS=0.69U PD=1.1U
* device instance $198 r0 *1 129.205,0.415 nfet
M$198 \$177 \$173 \$59 vsubs nfet L=0.15U W=0.36U AS=0.0999P AD=0.0711P
+ PS=0.985U PD=0.755U
* device instance $199 r0 *1 129.75,0.415 nfet
M$199 \$280 \$172 \$177 vsubs nfet L=0.15U W=0.36U AS=0.0711P AD=0.0669P
+ PS=0.755U PD=0.75U
* device instance $200 r0 *1 125.905,0.445 nfet
M$200 \$174 D$8 VGND vsubs nfet L=0.15U W=0.42U AS=0.2205P AD=0.066P PS=1.89U
+ PD=0.745U
* device instance $201 r0 *1 127.69,0.445 nfet
M$201 \$278 \$59 \$276 vsubs nfet L=0.15U W=0.42U AS=0.1401P AD=0.0441P PS=1.1U
+ PD=0.63U
* device instance $202 r0 *1 128.05,0.445 nfet
M$202 VGND RESET_B$6 \$278 vsubs nfet L=0.15U W=0.42U AS=0.0441P AD=0.1346P
+ PS=0.63U PD=1.15U
* device instance $203 r0 *1 130.23,0.445 nfet
M$203 VGND \$60 \$280 vsubs nfet L=0.15U W=0.42U AS=0.0669P AD=0.12495P
+ PS=0.75U PD=1.015U
* device instance $204 r0 *1 130.975,0.445 nfet
M$204 \$281 RESET_B$6 VGND vsubs nfet L=0.15U W=0.42U AS=0.12495P AD=0.06405P
+ PS=1.015U PD=0.725U
* device instance $205 r0 *1 131.43,0.445 nfet
M$205 \$60 \$177 \$281 vsubs nfet L=0.15U W=0.42U AS=0.06405P AD=0.1092P
+ PS=0.725U PD=1.36U
* device instance $206 r0 *1 128.71,0.555 nfet
M$206 \$59 \$175 VGND vsubs nfet L=0.15U W=0.64U AS=0.1346P AD=0.0999P PS=1.15U
+ PD=0.985U
* device instance $207 r0 *1 132.47,0.56 nfet
M$207 Q$6 \$60 VGND vsubs nfet L=0.15U W=0.65U AS=0.2087P AD=0.08775P PS=2.02U
+ PD=0.92U
* device instance $208 r0 *1 132.89,0.56 nfet
M$208 VGND \$60 Q$6 vsubs nfet L=0.15U W=0.65U AS=0.08775P AD=0.169P PS=0.92U
+ PD=1.82U
* device instance $209 r0 *1 134.06,0.585 nfet
M$209 \$282 A$25 \$179 vsubs nfet L=0.15U W=0.42U AS=0.1176P AD=0.0567P PS=1.4U
+ PD=0.69U
* device instance $210 r0 *1 134.48,0.585 nfet
M$210 \$282 B$17 VGND vsubs nfet L=0.15U W=0.42U AS=0.1118P AD=0.0567P PS=1.04U
+ PD=0.69U
* device instance $211 r0 *1 135.02,0.56 nfet
M$211 X$13 \$179 VGND vsubs nfet L=0.15U W=0.65U AS=0.1118P AD=0.12675P
+ PS=1.04U PD=1.04U
* device instance $212 r0 *1 135.56,0.56 nfet
M$212 VGND \$179 X$13 vsubs nfet L=0.15U W=0.65U AS=0.12675P AD=0.247P PS=1.04U
+ PD=2.06U
* device instance $213 r0 *1 136.64,0.56 nfet
M$213 Y$6 A$11 VGND vsubs nfet L=0.15U W=0.65U AS=0.169P AD=0.08775P PS=1.82U
+ PD=0.92U
* device instance $214 r0 *1 137.06,0.56 nfet
M$214 VGND A$11 Y$6 vsubs nfet L=0.15U W=0.65U AS=0.08775P AD=0.169P PS=0.92U
+ PD=1.82U
* device instance $215 r0 *1 138.01,0.445 nfet
M$215 VGND CLK$7 \$185 vsubs nfet L=0.15U W=0.42U AS=0.1092P AD=0.0567P
+ PS=1.36U PD=0.69U
* device instance $216 r0 *1 138.43,0.445 nfet
M$216 \$186 \$185 VGND vsubs nfet L=0.15U W=0.42U AS=0.0567P AD=0.1092P
+ PS=0.69U PD=1.36U
* device instance $217 r0 *1 140.18,0.415 nfet
M$217 \$188 \$185 \$187 vsubs nfet L=0.15U W=0.36U AS=0.066P AD=0.0594P
+ PS=0.745U PD=0.69U
* device instance $218 r0 *1 140.66,0.415 nfet
M$218 \$279 \$186 \$188 vsubs nfet L=0.15U W=0.36U AS=0.0594P AD=0.1401P
+ PS=0.69U PD=1.1U
* device instance $219 r0 *1 143.005,0.415 nfet
M$219 \$190 \$186 \$62 vsubs nfet L=0.15U W=0.36U AS=0.0999P AD=0.0711P
+ PS=0.985U PD=0.755U
* device instance $220 r0 *1 143.55,0.415 nfet
M$220 \$275 \$185 \$190 vsubs nfet L=0.15U W=0.36U AS=0.0711P AD=0.0669P
+ PS=0.755U PD=0.75U
* device instance $221 r0 *1 139.705,0.445 nfet
M$221 \$187 D$9 VGND vsubs nfet L=0.15U W=0.42U AS=0.2205P AD=0.066P PS=1.89U
+ PD=0.745U
* device instance $222 r0 *1 141.49,0.445 nfet
M$222 \$277 \$62 \$279 vsubs nfet L=0.15U W=0.42U AS=0.1401P AD=0.0441P PS=1.1U
+ PD=0.63U
* device instance $223 r0 *1 141.85,0.445 nfet
M$223 VGND RESET_B$7 \$277 vsubs nfet L=0.15U W=0.42U AS=0.0441P AD=0.1346P
+ PS=0.63U PD=1.15U
* device instance $224 r0 *1 144.03,0.445 nfet
M$224 VGND \$63 \$275 vsubs nfet L=0.15U W=0.42U AS=0.0669P AD=0.12495P
+ PS=0.75U PD=1.015U
* device instance $225 r0 *1 144.775,0.445 nfet
M$225 \$274 RESET_B$7 VGND vsubs nfet L=0.15U W=0.42U AS=0.12495P AD=0.06405P
+ PS=1.015U PD=0.725U
* device instance $226 r0 *1 145.23,0.445 nfet
M$226 \$63 \$190 \$274 vsubs nfet L=0.15U W=0.42U AS=0.06405P AD=0.1092P
+ PS=0.725U PD=1.36U
* device instance $227 r0 *1 142.51,0.555 nfet
M$227 \$62 \$188 VGND vsubs nfet L=0.15U W=0.64U AS=0.1346P AD=0.0999P PS=1.15U
+ PD=0.985U
* device instance $228 r0 *1 146.27,0.56 nfet
M$228 Q$7 \$63 VGND vsubs nfet L=0.15U W=0.65U AS=0.2087P AD=0.08775P PS=2.02U
+ PD=0.92U
* device instance $229 r0 *1 146.69,0.56 nfet
M$229 VGND \$63 Q$7 vsubs nfet L=0.15U W=0.65U AS=0.08775P AD=0.169P PS=0.92U
+ PD=1.82U
* device instance $230 r0 *1 147.86,0.585 nfet
M$230 \$270 A$26 \$192 vsubs nfet L=0.15U W=0.42U AS=0.1176P AD=0.0567P PS=1.4U
+ PD=0.69U
* device instance $231 r0 *1 148.28,0.585 nfet
M$231 \$270 B$18 VGND vsubs nfet L=0.15U W=0.42U AS=0.1118P AD=0.0567P PS=1.04U
+ PD=0.69U
* device instance $232 r0 *1 148.82,0.56 nfet
M$232 X$14 \$192 VGND vsubs nfet L=0.15U W=0.65U AS=0.1118P AD=0.12675P
+ PS=1.04U PD=1.04U
* device instance $233 r0 *1 149.36,0.56 nfet
M$233 VGND \$192 X$14 vsubs nfet L=0.15U W=0.65U AS=0.12675P AD=0.247P PS=1.04U
+ PD=2.06U
* device instance $234 r0 *1 150.43,0.445 nfet
M$234 VGND CLK$8 \$197 vsubs nfet L=0.15U W=0.42U AS=0.1092P AD=0.0567P
+ PS=1.36U PD=0.69U
* device instance $235 r0 *1 150.85,0.445 nfet
M$235 \$198 \$197 VGND vsubs nfet L=0.15U W=0.42U AS=0.0567P AD=0.1092P
+ PS=0.69U PD=1.36U
* device instance $236 r0 *1 152.35,0.415 nfet
M$236 \$200 \$197 \$199 vsubs nfet L=0.15U W=0.36U AS=0.0813P AD=0.0621P
+ PS=0.83U PD=0.705U
* device instance $237 r0 *1 152.845,0.415 nfet
M$237 \$267 \$198 \$200 vsubs nfet L=0.15U W=0.36U AS=0.0621P AD=0.0696P
+ PS=0.705U PD=0.765U
* device instance $238 r0 *1 154.44,0.415 nfet
M$238 \$201 \$198 \$64 vsubs nfet L=0.15U W=0.36U AS=0.0989P AD=0.0684P
+ PS=0.995U PD=0.74U
* device instance $239 r0 *1 154.97,0.415 nfet
M$239 \$264 \$197 \$201 vsubs nfet L=0.15U W=0.36U AS=0.0684P AD=0.066P
+ PS=0.74U PD=0.745U
* device instance $240 r0 *1 151.79,0.445 nfet
M$240 \$199 D$10 VGND vsubs nfet L=0.15U W=0.42U AS=0.1092P AD=0.0813P PS=1.36U
+ PD=0.83U
* device instance $241 r0 *1 153.34,0.445 nfet
M$241 VGND \$64 \$267 vsubs nfet L=0.15U W=0.42U AS=0.0696P AD=0.12095P
+ PS=0.765U PD=1.085U
* device instance $242 r0 *1 155.445,0.445 nfet
M$242 VGND \$202 \$264 vsubs nfet L=0.15U W=0.42U AS=0.066P AD=0.1092P
+ PS=0.745U PD=1.36U
* device instance $243 r0 *1 153.935,0.555 nfet
M$243 \$64 \$200 VGND vsubs nfet L=0.15U W=0.64U AS=0.12095P AD=0.0989P
+ PS=1.085U PD=0.995U
* device instance $244 r0 *1 156.39,0.56 nfet
M$244 VGND \$201 \$202 vsubs nfet L=0.15U W=0.65U AS=0.169P AD=0.08775P
+ PS=1.82U PD=0.92U
* device instance $245 r0 *1 156.81,0.56 nfet
M$245 Q$8 \$202 VGND vsubs nfet L=0.15U W=0.65U AS=0.08775P AD=0.08775P
+ PS=0.92U PD=0.92U
* device instance $246 r0 *1 157.23,0.56 nfet
M$246 VGND \$202 Q$8 vsubs nfet L=0.15U W=0.65U AS=0.08775P AD=0.169P PS=0.92U
+ PD=1.82U
* device instance $247 r0 *1 158.26,0.56 nfet
M$247 Y$7 A$12 VGND vsubs nfet L=0.15U W=0.65U AS=0.169P AD=0.08775P PS=1.82U
+ PD=0.92U
* device instance $248 r0 *1 158.68,0.56 nfet
M$248 VGND A$12 Y$7 vsubs nfet L=0.15U W=0.65U AS=0.08775P AD=0.169P PS=0.92U
+ PD=1.82U
* device instance $249 r0 *1 159.65,0.56 nfet
M$249 Y$8 A$13 VGND vsubs nfet L=0.15U W=0.65U AS=0.182P AD=0.08775P PS=1.86U
+ PD=0.92U
* device instance $250 r0 *1 160.07,0.56 nfet
M$250 VGND A$13 Y$8 vsubs nfet L=0.15U W=0.65U AS=0.08775P AD=0.08775P PS=0.92U
+ PD=0.92U
* device instance $251 r0 *1 160.49,0.56 nfet
M$251 Y$8 B$6 VGND vsubs nfet L=0.15U W=0.65U AS=0.08775P AD=0.08775P PS=0.92U
+ PD=0.92U
* device instance $252 r0 *1 160.91,0.56 nfet
M$252 VGND B$6 Y$8 vsubs nfet L=0.15U W=0.65U AS=0.08775P AD=0.169P PS=0.92U
+ PD=1.82U
* device instance $253 r0 *1 161.95,0.56 nfet
M$253 Y$9 A$14 VGND vsubs nfet L=0.15U W=0.65U AS=0.17875P AD=0.08775P PS=1.85U
+ PD=0.92U
* device instance $254 r0 *1 162.37,0.56 nfet
M$254 VGND A$14 Y$9 vsubs nfet L=0.15U W=0.65U AS=0.08775P AD=0.08775P PS=0.92U
+ PD=0.92U
* device instance $255 r0 *1 162.79,0.56 nfet
M$255 Y$9 B$7 VGND vsubs nfet L=0.15U W=0.65U AS=0.08775P AD=0.08775P PS=0.92U
+ PD=0.92U
* device instance $256 r0 *1 163.21,0.56 nfet
M$256 VGND B$7 Y$9 vsubs nfet L=0.15U W=0.65U AS=0.08775P AD=0.169P PS=0.92U
+ PD=1.82U
* device instance $257 r0 *1 164.17,0.56 nfet
M$257 Y$9 C$1 VGND vsubs nfet L=0.15U W=0.65U AS=0.169P AD=0.08775P PS=1.82U
+ PD=0.92U
* device instance $258 r0 *1 164.59,0.56 nfet
M$258 VGND C$1 Y$9 vsubs nfet L=0.15U W=0.65U AS=0.08775P AD=0.169P PS=0.92U
+ PD=1.82U
* device instance $259 r0 *1 165.63,0.56 nfet
M$259 Y$10 A$15 VGND vsubs nfet L=0.15U W=0.65U AS=0.182P AD=0.08775P PS=1.86U
+ PD=0.92U
* device instance $260 r0 *1 166.05,0.56 nfet
M$260 VGND A$15 Y$10 vsubs nfet L=0.15U W=0.65U AS=0.08775P AD=0.08775P
+ PS=0.92U PD=0.92U
* device instance $261 r0 *1 166.47,0.56 nfet
M$261 Y$10 B$8 VGND vsubs nfet L=0.15U W=0.65U AS=0.08775P AD=0.08775P PS=0.92U
+ PD=0.92U
* device instance $262 r0 *1 166.89,0.56 nfet
M$262 VGND B$8 Y$10 vsubs nfet L=0.15U W=0.65U AS=0.08775P AD=0.182P PS=0.92U
+ PD=1.86U
* device instance $263 r0 *1 167.87,0.56 nfet
M$263 Y$10 C$2 VGND vsubs nfet L=0.15U W=0.65U AS=0.182P AD=0.08775P PS=1.86U
+ PD=0.92U
* device instance $264 r0 *1 168.29,0.56 nfet
M$264 VGND C$2 Y$10 vsubs nfet L=0.15U W=0.65U AS=0.08775P AD=0.08775P PS=0.92U
+ PD=0.92U
* device instance $265 r0 *1 168.71,0.56 nfet
M$265 Y$10 D$1 VGND vsubs nfet L=0.15U W=0.65U AS=0.08775P AD=0.08775P PS=0.92U
+ PD=0.92U
* device instance $266 r0 *1 169.13,0.56 nfet
M$266 VGND D$1 Y$10 vsubs nfet L=0.15U W=0.65U AS=0.08775P AD=0.169P PS=0.92U
+ PD=1.82U
* device instance $267 r0 *1 170.22,0.56 nfet
M$267 Y$11 A$16 VGND vsubs nfet L=0.15U W=0.65U AS=0.169P AD=0.08775P PS=1.82U
+ PD=0.92U
* device instance $268 r0 *1 170.64,0.56 nfet
M$268 VGND A$16 Y$11 vsubs nfet L=0.15U W=0.65U AS=0.08775P AD=0.169P PS=0.92U
+ PD=1.82U
* device instance $269 r0 *1 171.78,0.585 nfet
M$269 \$250 A$27 \$209 vsubs nfet L=0.15U W=0.42U AS=0.1176P AD=0.0567P PS=1.4U
+ PD=0.69U
* device instance $270 r0 *1 172.2,0.585 nfet
M$270 \$250 B$19 VGND vsubs nfet L=0.15U W=0.42U AS=0.1118P AD=0.0567P PS=1.04U
+ PD=0.69U
* device instance $271 r0 *1 172.74,0.56 nfet
M$271 X$15 \$209 VGND vsubs nfet L=0.15U W=0.65U AS=0.1118P AD=0.12675P
+ PS=1.04U PD=1.04U
* device instance $272 r0 *1 173.28,0.56 nfet
M$272 VGND \$209 X$15 vsubs nfet L=0.15U W=0.65U AS=0.12675P AD=0.247P PS=1.04U
+ PD=2.06U
* device instance $273 r0 *1 174.365,0.56 nfet
M$273 \$214 B$9 \$213 vsubs nfet L=0.15U W=0.65U AS=0.17875P AD=0.08775P
+ PS=1.85U PD=0.92U
* device instance $274 r0 *1 174.785,0.56 nfet
M$274 \$213 B$9 \$214 vsubs nfet L=0.15U W=0.65U AS=0.08775P AD=0.08775P
+ PS=0.92U PD=0.92U
* device instance $275 r0 *1 175.205,0.56 nfet
M$275 VGND A$17 \$213 vsubs nfet L=0.15U W=0.65U AS=0.08775P AD=0.08775P
+ PS=0.92U PD=0.92U
* device instance $276 r0 *1 175.625,0.56 nfet
M$276 \$213 A$17 VGND vsubs nfet L=0.15U W=0.65U AS=0.08775P AD=0.182P PS=0.92U
+ PD=1.86U
* device instance $277 r0 *1 176.605,0.56 nfet
M$277 \$215 A$17 VGND vsubs nfet L=0.15U W=0.65U AS=0.182P AD=0.08775P PS=1.86U
+ PD=0.92U
* device instance $278 r0 *1 177.025,0.56 nfet
M$278 VGND A$17 \$215 vsubs nfet L=0.15U W=0.65U AS=0.08775P AD=0.08775P
+ PS=0.92U PD=0.92U
* device instance $279 r0 *1 177.445,0.56 nfet
M$279 \$215 B$9 VGND vsubs nfet L=0.15U W=0.65U AS=0.08775P AD=0.099125P
+ PS=0.92U PD=0.955U
* device instance $280 r0 *1 177.9,0.56 nfet
M$280 VGND B$9 \$215 vsubs nfet L=0.15U W=0.65U AS=0.099125P AD=0.169P
+ PS=0.955U PD=1.82U
* device instance $281 r0 *1 178.84,0.56 nfet
M$281 \$215 \$214 Y$12 vsubs nfet L=0.15U W=0.65U AS=0.169P AD=0.08775P
+ PS=1.82U PD=0.92U
* device instance $282 r0 *1 179.26,0.56 nfet
M$282 Y$12 \$214 \$215 vsubs nfet L=0.15U W=0.65U AS=0.08775P AD=0.169P
+ PS=0.92U PD=1.82U
* device instance $283 r0 *1 180.345,0.56 nfet
M$283 \$217 A$18 VGND vsubs nfet L=0.15U W=0.65U AS=0.17875P AD=0.08775P
+ PS=1.85U PD=0.92U
* device instance $284 r0 *1 180.765,0.56 nfet
M$284 VGND A$18 \$217 vsubs nfet L=0.15U W=0.65U AS=0.08775P AD=0.08775P
+ PS=0.92U PD=0.92U
* device instance $285 r0 *1 181.185,0.56 nfet
M$285 \$217 B$10 VGND vsubs nfet L=0.15U W=0.65U AS=0.08775P AD=0.08775P
+ PS=0.92U PD=0.92U
* device instance $286 r0 *1 181.605,0.56 nfet
M$286 VGND B$10 \$217 vsubs nfet L=0.15U W=0.65U AS=0.08775P AD=0.169P PS=0.92U
+ PD=1.82U
* device instance $287 r0 *1 182.545,0.56 nfet
M$287 VGND A$18 \$218 vsubs nfet L=0.15U W=0.65U AS=0.169P AD=0.08775P PS=1.82U
+ PD=0.92U
* device instance $288 r0 *1 182.965,0.56 nfet
M$288 \$218 A$18 VGND vsubs nfet L=0.15U W=0.65U AS=0.08775P AD=0.08775P
+ PS=0.92U PD=0.92U
* device instance $289 r0 *1 183.385,0.56 nfet
M$289 X$16 B$10 \$218 vsubs nfet L=0.15U W=0.65U AS=0.08775P AD=0.105625P
+ PS=0.92U PD=0.975U
* device instance $290 r0 *1 183.86,0.56 nfet
M$290 \$218 B$10 X$16 vsubs nfet L=0.15U W=0.65U AS=0.105625P AD=0.169P
+ PS=0.975U PD=1.82U
* device instance $291 r0 *1 184.8,0.56 nfet
M$291 X$16 \$217 VGND vsubs nfet L=0.15U W=0.65U AS=0.169P AD=0.08775P PS=1.82U
+ PD=0.92U
* device instance $292 r0 *1 185.22,0.56 nfet
M$292 VGND \$217 X$16 vsubs nfet L=0.15U W=0.65U AS=0.08775P AD=0.169P PS=0.92U
+ PD=1.82U
* device instance $293 r0 *1 186.325,0.56 nfet
M$293 \$220 A$19 VGND vsubs nfet L=0.15U W=0.65U AS=0.17875P AD=0.08775P
+ PS=1.85U PD=0.92U
* device instance $294 r0 *1 186.745,0.56 nfet
M$294 VGND A$19 \$220 vsubs nfet L=0.15U W=0.65U AS=0.08775P AD=0.08775P
+ PS=0.92U PD=0.92U
* device instance $295 r0 *1 187.165,0.56 nfet
M$295 \$220 B$11 VGND vsubs nfet L=0.15U W=0.65U AS=0.08775P AD=0.08775P
+ PS=0.92U PD=0.92U
* device instance $296 r0 *1 187.585,0.56 nfet
M$296 VGND B$11 \$220 vsubs nfet L=0.15U W=0.65U AS=0.08775P AD=0.169P PS=0.92U
+ PD=1.82U
* device instance $297 r0 *1 188.525,0.56 nfet
M$297 VGND A$19 \$221 vsubs nfet L=0.15U W=0.65U AS=0.169P AD=0.08775P PS=1.82U
+ PD=0.92U
* device instance $298 r0 *1 188.945,0.56 nfet
M$298 \$221 A$19 VGND vsubs nfet L=0.15U W=0.65U AS=0.08775P AD=0.08775P
+ PS=0.92U PD=0.92U
* device instance $299 r0 *1 189.365,0.56 nfet
M$299 X$17 B$11 \$221 vsubs nfet L=0.15U W=0.65U AS=0.08775P AD=0.105625P
+ PS=0.92U PD=0.975U
* device instance $300 r0 *1 189.84,0.56 nfet
M$300 \$221 B$11 X$17 vsubs nfet L=0.15U W=0.65U AS=0.105625P AD=0.169P
+ PS=0.975U PD=1.82U
* device instance $301 r0 *1 190.78,0.56 nfet
M$301 X$17 \$220 VGND vsubs nfet L=0.15U W=0.65U AS=0.169P AD=0.08775P PS=1.82U
+ PD=0.92U
* device instance $302 r0 *1 191.2,0.56 nfet
M$302 VGND \$220 X$17 vsubs nfet L=0.15U W=0.65U AS=0.08775P AD=0.169P PS=0.92U
+ PD=1.82U
* device instance $303 r0 *1 192.305,0.56 nfet
M$303 \$223 A$20 VGND vsubs nfet L=0.15U W=0.65U AS=0.17875P AD=0.08775P
+ PS=1.85U PD=0.92U
* device instance $304 r0 *1 192.725,0.56 nfet
M$304 VGND A$20 \$223 vsubs nfet L=0.15U W=0.65U AS=0.08775P AD=0.08775P
+ PS=0.92U PD=0.92U
* device instance $305 r0 *1 193.145,0.56 nfet
M$305 \$223 B$12 VGND vsubs nfet L=0.15U W=0.65U AS=0.08775P AD=0.08775P
+ PS=0.92U PD=0.92U
* device instance $306 r0 *1 193.565,0.56 nfet
M$306 VGND B$12 \$223 vsubs nfet L=0.15U W=0.65U AS=0.08775P AD=0.169P PS=0.92U
+ PD=1.82U
* device instance $307 r0 *1 194.505,0.56 nfet
M$307 VGND A$20 \$224 vsubs nfet L=0.15U W=0.65U AS=0.169P AD=0.08775P PS=1.82U
+ PD=0.92U
* device instance $308 r0 *1 194.925,0.56 nfet
M$308 \$224 A$20 VGND vsubs nfet L=0.15U W=0.65U AS=0.08775P AD=0.08775P
+ PS=0.92U PD=0.92U
* device instance $309 r0 *1 195.345,0.56 nfet
M$309 X$18 B$12 \$224 vsubs nfet L=0.15U W=0.65U AS=0.08775P AD=0.105625P
+ PS=0.92U PD=0.975U
* device instance $310 r0 *1 195.82,0.56 nfet
M$310 \$224 B$12 X$18 vsubs nfet L=0.15U W=0.65U AS=0.105625P AD=0.169P
+ PS=0.975U PD=1.82U
* device instance $311 r0 *1 196.76,0.56 nfet
M$311 X$18 \$223 VGND vsubs nfet L=0.15U W=0.65U AS=0.169P AD=0.08775P PS=1.82U
+ PD=0.92U
* device instance $312 r0 *1 197.18,0.56 nfet
M$312 VGND \$223 X$18 vsubs nfet L=0.15U W=0.65U AS=0.08775P AD=0.169P PS=0.92U
+ PD=1.82U
* device instance $313 r0 *1 198.285,0.56 nfet
M$313 \$226 A$21 VGND vsubs nfet L=0.15U W=0.65U AS=0.17875P AD=0.08775P
+ PS=1.85U PD=0.92U
* device instance $314 r0 *1 198.705,0.56 nfet
M$314 VGND A$21 \$226 vsubs nfet L=0.15U W=0.65U AS=0.08775P AD=0.08775P
+ PS=0.92U PD=0.92U
* device instance $315 r0 *1 199.125,0.56 nfet
M$315 \$226 B$13 VGND vsubs nfet L=0.15U W=0.65U AS=0.08775P AD=0.08775P
+ PS=0.92U PD=0.92U
* device instance $316 r0 *1 199.545,0.56 nfet
M$316 VGND B$13 \$226 vsubs nfet L=0.15U W=0.65U AS=0.08775P AD=0.169P PS=0.92U
+ PD=1.82U
* device instance $317 r0 *1 200.485,0.56 nfet
M$317 VGND A$21 \$227 vsubs nfet L=0.15U W=0.65U AS=0.169P AD=0.08775P PS=1.82U
+ PD=0.92U
* device instance $318 r0 *1 200.905,0.56 nfet
M$318 \$227 A$21 VGND vsubs nfet L=0.15U W=0.65U AS=0.08775P AD=0.08775P
+ PS=0.92U PD=0.92U
* device instance $319 r0 *1 201.325,0.56 nfet
M$319 X$19 B$13 \$227 vsubs nfet L=0.15U W=0.65U AS=0.08775P AD=0.105625P
+ PS=0.92U PD=0.975U
* device instance $320 r0 *1 201.8,0.56 nfet
M$320 \$227 B$13 X$19 vsubs nfet L=0.15U W=0.65U AS=0.105625P AD=0.169P
+ PS=0.975U PD=1.82U
* device instance $321 r0 *1 202.74,0.56 nfet
M$321 X$19 \$226 VGND vsubs nfet L=0.15U W=0.65U AS=0.169P AD=0.08775P PS=1.82U
+ PD=0.92U
* device instance $322 r0 *1 203.16,0.56 nfet
M$322 VGND \$226 X$19 vsubs nfet L=0.15U W=0.65U AS=0.08775P AD=0.169P PS=0.92U
+ PD=1.82U
* device instance $323 r0 *1 80.525,0.475 nfet
M$323 \$255 A$23 \$138 vsubs nfet L=0.15U W=0.42U AS=0.1092P AD=0.0441P
+ PS=1.36U PD=0.63U
* device instance $324 r0 *1 80.885,0.475 nfet
M$324 \$256 B$15 \$255 vsubs nfet L=0.15U W=0.42U AS=0.0441P AD=0.05355P
+ PS=0.63U PD=0.675U
* device instance $325 r0 *1 81.29,0.475 nfet
M$325 \$256 C$3 VGND vsubs nfet L=0.15U W=0.42U AS=0.1304P AD=0.05355P
+ PS=1.105U PD=0.675U
* device instance $326 r0 *1 81.895,0.56 nfet
M$326 X$8 \$138 VGND vsubs nfet L=0.15U W=0.65U AS=0.1304P AD=0.08775P
+ PS=1.105U PD=0.92U
* device instance $327 r0 *1 82.315,0.56 nfet
M$327 VGND \$138 X$8 vsubs nfet L=0.15U W=0.65U AS=0.08775P AD=0.17875P
+ PS=0.92U PD=1.85U
* device instance $328 r0 *1 8.73,1.985 pfet
M$328 Q \$3 VPWR VPB pfet L=0.15U W=1U AS=0.3012P AD=0.135P PS=2.66U PD=1.27U
* device instance $329 r0 *1 9.15,1.985 pfet
M$329 VPWR \$3 Q VPB pfet L=0.15U W=1U AS=0.135P AD=0.26P PS=1.27U PD=2.52U
* device instance $330 r0 *1 10.13,1.985 pfet
M$330 X \$4 VPWR VPB pfet L=0.15U W=1U AS=0.26P AD=0.135P PS=2.52U PD=1.27U
* device instance $331 r0 *1 10.55,1.985 pfet
M$331 VPWR \$4 X VPB pfet L=0.15U W=1U AS=0.135P AD=0.1778P PS=1.27U PD=1.415U
* device instance $332 r0 *1 11.115,2.165 pfet
M$332 \$327 \$5 VPWR VPB pfet L=0.15U W=0.64U AS=0.1778P AD=0.2288P PS=1.415U
+ PD=1.355U
* device instance $333 r0 *1 11.98,2.165 pfet
M$333 \$4 A1 \$327 VPB pfet L=0.15U W=0.64U AS=0.2288P AD=0.1312P PS=1.355U
+ PD=1.05U
* device instance $334 r0 *1 12.54,2.165 pfet
M$334 \$328 A0 \$4 VPB pfet L=0.15U W=0.64U AS=0.1312P AD=0.0672P PS=1.05U
+ PD=0.85U
* device instance $335 r0 *1 12.9,2.165 pfet
M$335 VPWR S \$328 VPB pfet L=0.15U W=0.64U AS=0.0672P AD=0.0864P PS=0.85U
+ PD=0.91U
* device instance $336 r0 *1 13.32,2.165 pfet
M$336 \$5 S VPWR VPB pfet L=0.15U W=0.64U AS=0.0864P AD=0.1728P PS=0.91U
+ PD=1.82U
* device instance $337 r0 *1 14.28,1.985 pfet
M$337 Y A VPWR VPB pfet L=0.15U W=1U AS=0.26P AD=0.135P PS=2.52U PD=1.27U
* device instance $338 r0 *1 14.7,1.985 pfet
M$338 VPWR A Y VPB pfet L=0.15U W=1U AS=0.135P AD=0.26P PS=1.27U PD=2.52U
* device instance $339 r0 *1 23.91,1.985 pfet
M$339 Q$1 \$11 VPWR VPB pfet L=0.15U W=1U AS=0.3012P AD=0.135P PS=2.66U PD=1.27U
* device instance $340 r0 *1 24.33,1.985 pfet
M$340 VPWR \$11 Q$1 VPB pfet L=0.15U W=1U AS=0.135P AD=0.26P PS=1.27U PD=2.52U
* device instance $341 r0 *1 25.31,1.985 pfet
M$341 X$1 \$12 VPWR VPB pfet L=0.15U W=1U AS=0.26P AD=0.135P PS=2.52U PD=1.27U
* device instance $342 r0 *1 25.73,1.985 pfet
M$342 VPWR \$12 X$1 VPB pfet L=0.15U W=1U AS=0.135P AD=0.1778P PS=1.27U
+ PD=1.415U
* device instance $343 r0 *1 26.295,2.165 pfet
M$343 \$330 \$13 VPWR VPB pfet L=0.15U W=0.64U AS=0.1778P AD=0.2288P PS=1.415U
+ PD=1.355U
* device instance $344 r0 *1 27.16,2.165 pfet
M$344 \$12 A1$1 \$330 VPB pfet L=0.15U W=0.64U AS=0.2288P AD=0.1312P PS=1.355U
+ PD=1.05U
* device instance $345 r0 *1 27.72,2.165 pfet
M$345 \$331 A0$1 \$12 VPB pfet L=0.15U W=0.64U AS=0.1312P AD=0.0672P PS=1.05U
+ PD=0.85U
* device instance $346 r0 *1 28.08,2.165 pfet
M$346 VPWR S$1 \$331 VPB pfet L=0.15U W=0.64U AS=0.0672P AD=0.0864P PS=0.85U
+ PD=0.91U
* device instance $347 r0 *1 28.5,2.165 pfet
M$347 \$13 S$1 VPWR VPB pfet L=0.15U W=0.64U AS=0.0864P AD=0.1728P PS=0.91U
+ PD=1.82U
* device instance $348 r0 *1 29.465,1.985 pfet
M$348 VPWR A$1 \$311 VPB pfet L=0.15U W=1U AS=0.275P AD=0.135P PS=2.55U PD=1.27U
* device instance $349 r0 *1 29.885,1.985 pfet
M$349 \$311 A$1 VPWR VPB pfet L=0.15U W=1U AS=0.135P AD=0.135P PS=1.27U PD=1.27U
* device instance $350 r0 *1 30.305,1.985 pfet
M$350 \$105 B \$311 VPB pfet L=0.15U W=1U AS=0.135P AD=0.135P PS=1.27U PD=1.27U
* device instance $351 r0 *1 30.725,1.985 pfet
M$351 \$311 B \$105 VPB pfet L=0.15U W=1U AS=0.135P AD=0.26P PS=1.27U PD=2.52U
* device instance $352 r0 *1 31.665,1.985 pfet
M$352 VPWR A$1 \$293 VPB pfet L=0.15U W=1U AS=0.26P AD=0.135P PS=2.52U PD=1.27U
* device instance $353 r0 *1 32.085,1.985 pfet
M$353 \$293 A$1 VPWR VPB pfet L=0.15U W=1U AS=0.135P AD=0.135P PS=1.27U PD=1.27U
* device instance $354 r0 *1 32.505,1.985 pfet
M$354 VPWR B \$293 VPB pfet L=0.15U W=1U AS=0.135P AD=0.1625P PS=1.27U PD=1.325U
* device instance $355 r0 *1 32.98,1.985 pfet
M$355 \$293 B VPWR VPB pfet L=0.15U W=1U AS=0.1625P AD=0.26P PS=1.325U PD=2.52U
* device instance $356 r0 *1 33.92,1.985 pfet
M$356 X$2 \$105 \$293 VPB pfet L=0.15U W=1U AS=0.26P AD=0.135P PS=2.52U PD=1.27U
* device instance $357 r0 *1 34.34,1.985 pfet
M$357 \$293 \$105 X$2 VPB pfet L=0.15U W=1U AS=0.135P AD=0.28P PS=1.27U PD=2.56U
* device instance $358 r0 *1 35.44,1.985 pfet
M$358 Y$1 A$2 VPWR VPB pfet L=0.15U W=1U AS=0.26P AD=0.135P PS=2.52U PD=1.27U
* device instance $359 r0 *1 35.86,1.985 pfet
M$359 VPWR A$2 Y$1 VPB pfet L=0.15U W=1U AS=0.135P AD=0.26P PS=1.27U PD=2.52U
* device instance $360 r0 *1 45.07,1.985 pfet
M$360 Q$2 \$21 VPWR VPB pfet L=0.15U W=1U AS=0.3012P AD=0.135P PS=2.66U PD=1.27U
* device instance $361 r0 *1 45.49,1.985 pfet
M$361 VPWR \$21 Q$2 VPB pfet L=0.15U W=1U AS=0.135P AD=0.26P PS=1.27U PD=2.52U
* device instance $362 r0 *1 46.47,1.985 pfet
M$362 X$3 \$22 VPWR VPB pfet L=0.15U W=1U AS=0.26P AD=0.135P PS=2.52U PD=1.27U
* device instance $363 r0 *1 46.89,1.985 pfet
M$363 VPWR \$22 X$3 VPB pfet L=0.15U W=1U AS=0.135P AD=0.1778P PS=1.27U
+ PD=1.415U
* device instance $364 r0 *1 47.455,2.165 pfet
M$364 \$333 \$23 VPWR VPB pfet L=0.15U W=0.64U AS=0.1778P AD=0.2288P PS=1.415U
+ PD=1.355U
* device instance $365 r0 *1 48.32,2.165 pfet
M$365 \$22 A1$2 \$333 VPB pfet L=0.15U W=0.64U AS=0.2288P AD=0.1312P PS=1.355U
+ PD=1.05U
* device instance $366 r0 *1 48.88,2.165 pfet
M$366 \$334 A0$2 \$22 VPB pfet L=0.15U W=0.64U AS=0.1312P AD=0.0672P PS=1.05U
+ PD=0.85U
* device instance $367 r0 *1 49.24,2.165 pfet
M$367 VPWR S$2 \$334 VPB pfet L=0.15U W=0.64U AS=0.0672P AD=0.0864P PS=0.85U
+ PD=0.91U
* device instance $368 r0 *1 49.66,2.165 pfet
M$368 \$23 S$2 VPWR VPB pfet L=0.15U W=0.64U AS=0.0864P AD=0.1728P PS=0.91U
+ PD=1.82U
* device instance $369 r0 *1 50.625,1.985 pfet
M$369 VPWR A$3 \$313 VPB pfet L=0.15U W=1U AS=0.275P AD=0.135P PS=2.55U PD=1.27U
* device instance $370 r0 *1 51.045,1.985 pfet
M$370 \$313 A$3 VPWR VPB pfet L=0.15U W=1U AS=0.135P AD=0.135P PS=1.27U PD=1.27U
* device instance $371 r0 *1 51.465,1.985 pfet
M$371 \$118 B$1 \$313 VPB pfet L=0.15U W=1U AS=0.135P AD=0.135P PS=1.27U
+ PD=1.27U
* device instance $372 r0 *1 51.885,1.985 pfet
M$372 \$313 B$1 \$118 VPB pfet L=0.15U W=1U AS=0.135P AD=0.26P PS=1.27U PD=2.52U
* device instance $373 r0 *1 52.825,1.985 pfet
M$373 VPWR A$3 \$294 VPB pfet L=0.15U W=1U AS=0.26P AD=0.135P PS=2.52U PD=1.27U
* device instance $374 r0 *1 53.245,1.985 pfet
M$374 \$294 A$3 VPWR VPB pfet L=0.15U W=1U AS=0.135P AD=0.135P PS=1.27U PD=1.27U
* device instance $375 r0 *1 53.665,1.985 pfet
M$375 VPWR B$1 \$294 VPB pfet L=0.15U W=1U AS=0.135P AD=0.1625P PS=1.27U
+ PD=1.325U
* device instance $376 r0 *1 54.14,1.985 pfet
M$376 \$294 B$1 VPWR VPB pfet L=0.15U W=1U AS=0.1625P AD=0.26P PS=1.325U
+ PD=2.52U
* device instance $377 r0 *1 55.08,1.985 pfet
M$377 X$4 \$118 \$294 VPB pfet L=0.15U W=1U AS=0.26P AD=0.135P PS=2.52U PD=1.27U
* device instance $378 r0 *1 55.5,1.985 pfet
M$378 \$294 \$118 X$4 VPB pfet L=0.15U W=1U AS=0.135P AD=0.28P PS=1.27U PD=2.56U
* device instance $379 r0 *1 56.78,2.065 pfet
M$379 \$121 A$22 VPWR VPB pfet L=0.15U W=0.42U AS=0.1176P AD=0.0567P PS=1.4U
+ PD=0.69U
* device instance $380 r0 *1 57.2,2.065 pfet
M$380 \$121 B$14 VPWR VPB pfet L=0.15U W=0.42U AS=0.16655P AD=0.0567P PS=1.39U
+ PD=0.69U
* device instance $381 r0 *1 57.74,1.985 pfet
M$381 X$5 \$121 VPWR VPB pfet L=0.15U W=1U AS=0.16655P AD=0.195P PS=1.39U
+ PD=1.39U
* device instance $382 r0 *1 58.28,1.985 pfet
M$382 VPWR \$121 X$5 VPB pfet L=0.15U W=1U AS=0.195P AD=0.38P PS=1.39U PD=2.76U
* device instance $383 r0 *1 59.36,1.985 pfet
M$383 Y$2 A$4 VPWR VPB pfet L=0.15U W=1U AS=0.26P AD=0.135P PS=2.52U PD=1.27U
* device instance $384 r0 *1 59.78,1.985 pfet
M$384 VPWR A$4 Y$2 VPB pfet L=0.15U W=1U AS=0.135P AD=0.26P PS=1.27U PD=2.52U
* device instance $385 r0 *1 68.99,1.985 pfet
M$385 Q$3 \$31 VPWR VPB pfet L=0.15U W=1U AS=0.3012P AD=0.135P PS=2.66U PD=1.27U
* device instance $386 r0 *1 69.41,1.985 pfet
M$386 VPWR \$31 Q$3 VPB pfet L=0.15U W=1U AS=0.135P AD=0.26P PS=1.27U PD=2.52U
* device instance $387 r0 *1 70.39,1.985 pfet
M$387 X$6 \$32 VPWR VPB pfet L=0.15U W=1U AS=0.26P AD=0.135P PS=2.52U PD=1.27U
* device instance $388 r0 *1 70.81,1.985 pfet
M$388 VPWR \$32 X$6 VPB pfet L=0.15U W=1U AS=0.135P AD=0.1778P PS=1.27U
+ PD=1.415U
* device instance $389 r0 *1 71.375,2.165 pfet
M$389 \$336 \$33 VPWR VPB pfet L=0.15U W=0.64U AS=0.1778P AD=0.2288P PS=1.415U
+ PD=1.355U
* device instance $390 r0 *1 72.24,2.165 pfet
M$390 \$32 A1$3 \$336 VPB pfet L=0.15U W=0.64U AS=0.2288P AD=0.1312P PS=1.355U
+ PD=1.05U
* device instance $391 r0 *1 72.8,2.165 pfet
M$391 \$337 A0$3 \$32 VPB pfet L=0.15U W=0.64U AS=0.1312P AD=0.0672P PS=1.05U
+ PD=0.85U
* device instance $392 r0 *1 73.16,2.165 pfet
M$392 VPWR S$3 \$337 VPB pfet L=0.15U W=0.64U AS=0.0672P AD=0.0864P PS=0.85U
+ PD=0.91U
* device instance $393 r0 *1 73.58,2.165 pfet
M$393 \$33 S$3 VPWR VPB pfet L=0.15U W=0.64U AS=0.0864P AD=0.1728P PS=0.91U
+ PD=1.82U
* device instance $394 r0 *1 74.545,1.985 pfet
M$394 VPWR A$5 \$315 VPB pfet L=0.15U W=1U AS=0.275P AD=0.135P PS=2.55U PD=1.27U
* device instance $395 r0 *1 74.965,1.985 pfet
M$395 \$315 A$5 VPWR VPB pfet L=0.15U W=1U AS=0.135P AD=0.135P PS=1.27U PD=1.27U
* device instance $396 r0 *1 75.385,1.985 pfet
M$396 \$135 B$2 \$315 VPB pfet L=0.15U W=1U AS=0.135P AD=0.135P PS=1.27U
+ PD=1.27U
* device instance $397 r0 *1 75.805,1.985 pfet
M$397 \$315 B$2 \$135 VPB pfet L=0.15U W=1U AS=0.135P AD=0.26P PS=1.27U PD=2.52U
* device instance $398 r0 *1 76.745,1.985 pfet
M$398 VPWR A$5 \$295 VPB pfet L=0.15U W=1U AS=0.26P AD=0.135P PS=2.52U PD=1.27U
* device instance $399 r0 *1 77.165,1.985 pfet
M$399 \$295 A$5 VPWR VPB pfet L=0.15U W=1U AS=0.135P AD=0.135P PS=1.27U PD=1.27U
* device instance $400 r0 *1 77.585,1.985 pfet
M$400 VPWR B$2 \$295 VPB pfet L=0.15U W=1U AS=0.135P AD=0.1625P PS=1.27U
+ PD=1.325U
* device instance $401 r0 *1 78.06,1.985 pfet
M$401 \$295 B$2 VPWR VPB pfet L=0.15U W=1U AS=0.1625P AD=0.26P PS=1.325U
+ PD=2.52U
* device instance $402 r0 *1 79,1.985 pfet
M$402 X$7 \$135 \$295 VPB pfet L=0.15U W=1U AS=0.26P AD=0.135P PS=2.52U PD=1.27U
* device instance $403 r0 *1 79.42,1.985 pfet
M$403 \$295 \$135 X$7 VPB pfet L=0.15U W=1U AS=0.135P AD=0.28P PS=1.27U PD=2.56U
* device instance $404 r0 *1 81.415,1.695 pfet
M$404 VPWR C$3 \$138 VPB pfet L=0.15U W=0.42U AS=0.074375P AD=0.15075P
+ PS=0.815U PD=1.345U
* device instance $405 r0 *1 80.52,1.765 pfet
M$405 VPWR A$23 \$138 VPB pfet L=0.15U W=0.42U AS=0.1092P AD=0.0567P PS=1.36U
+ PD=0.69U
* device instance $406 r0 *1 80.94,1.765 pfet
M$406 VPWR B$15 \$138 VPB pfet L=0.15U W=0.42U AS=0.074375P AD=0.0567P
+ PS=0.815U PD=0.69U
* device instance $407 r0 *1 81.91,1.985 pfet
M$407 X$8 \$138 VPWR VPB pfet L=0.15U W=1U AS=0.15075P AD=0.135P PS=1.345U
+ PD=1.27U
* device instance $408 r0 *1 82.33,1.985 pfet
M$408 VPWR \$138 X$8 VPB pfet L=0.15U W=1U AS=0.135P AD=0.26P PS=1.27U PD=2.52U
* device instance $409 r0 *1 83.28,1.985 pfet
M$409 Y$3 A$6 VPWR VPB pfet L=0.15U W=1U AS=0.26P AD=0.135P PS=2.52U PD=1.27U
* device instance $410 r0 *1 83.7,1.985 pfet
M$410 VPWR A$6 Y$3 VPB pfet L=0.15U W=1U AS=0.135P AD=0.26P PS=1.27U PD=2.52U
* device instance $411 r0 *1 92.91,1.985 pfet
M$411 Q$4 \$41 VPWR VPB pfet L=0.15U W=1U AS=0.3012P AD=0.135P PS=2.66U PD=1.27U
* device instance $412 r0 *1 93.33,1.985 pfet
M$412 VPWR \$41 Q$4 VPB pfet L=0.15U W=1U AS=0.135P AD=0.26P PS=1.27U PD=2.52U
* device instance $413 r0 *1 94.31,1.985 pfet
M$413 X$9 \$42 VPWR VPB pfet L=0.15U W=1U AS=0.26P AD=0.135P PS=2.52U PD=1.27U
* device instance $414 r0 *1 94.73,1.985 pfet
M$414 VPWR \$42 X$9 VPB pfet L=0.15U W=1U AS=0.135P AD=0.1778P PS=1.27U
+ PD=1.415U
* device instance $415 r0 *1 95.295,2.165 pfet
M$415 \$339 \$43 VPWR VPB pfet L=0.15U W=0.64U AS=0.1778P AD=0.2288P PS=1.415U
+ PD=1.355U
* device instance $416 r0 *1 96.16,2.165 pfet
M$416 \$42 A1$4 \$339 VPB pfet L=0.15U W=0.64U AS=0.2288P AD=0.1312P PS=1.355U
+ PD=1.05U
* device instance $417 r0 *1 96.72,2.165 pfet
M$417 \$340 A0$4 \$42 VPB pfet L=0.15U W=0.64U AS=0.1312P AD=0.0672P PS=1.05U
+ PD=0.85U
* device instance $418 r0 *1 97.08,2.165 pfet
M$418 VPWR S$4 \$340 VPB pfet L=0.15U W=0.64U AS=0.0672P AD=0.0864P PS=0.85U
+ PD=0.91U
* device instance $419 r0 *1 97.5,2.165 pfet
M$419 \$43 S$4 VPWR VPB pfet L=0.15U W=0.64U AS=0.0864P AD=0.1728P PS=0.91U
+ PD=1.82U
* device instance $420 r0 *1 98.465,1.985 pfet
M$420 VPWR A$7 \$317 VPB pfet L=0.15U W=1U AS=0.275P AD=0.135P PS=2.55U PD=1.27U
* device instance $421 r0 *1 98.885,1.985 pfet
M$421 \$317 A$7 VPWR VPB pfet L=0.15U W=1U AS=0.135P AD=0.135P PS=1.27U PD=1.27U
* device instance $422 r0 *1 99.305,1.985 pfet
M$422 \$153 B$3 \$317 VPB pfet L=0.15U W=1U AS=0.135P AD=0.135P PS=1.27U
+ PD=1.27U
* device instance $423 r0 *1 99.725,1.985 pfet
M$423 \$317 B$3 \$153 VPB pfet L=0.15U W=1U AS=0.135P AD=0.26P PS=1.27U PD=2.52U
* device instance $424 r0 *1 100.665,1.985 pfet
M$424 VPWR A$7 \$296 VPB pfet L=0.15U W=1U AS=0.26P AD=0.135P PS=2.52U PD=1.27U
* device instance $425 r0 *1 101.085,1.985 pfet
M$425 \$296 A$7 VPWR VPB pfet L=0.15U W=1U AS=0.135P AD=0.135P PS=1.27U PD=1.27U
* device instance $426 r0 *1 101.505,1.985 pfet
M$426 VPWR B$3 \$296 VPB pfet L=0.15U W=1U AS=0.135P AD=0.1625P PS=1.27U
+ PD=1.325U
* device instance $427 r0 *1 101.98,1.985 pfet
M$427 \$296 B$3 VPWR VPB pfet L=0.15U W=1U AS=0.1625P AD=0.26P PS=1.325U
+ PD=2.52U
* device instance $428 r0 *1 102.92,1.985 pfet
M$428 X$10 \$153 \$296 VPB pfet L=0.15U W=1U AS=0.26P AD=0.135P PS=2.52U
+ PD=1.27U
* device instance $429 r0 *1 103.34,1.985 pfet
M$429 \$296 \$153 X$10 VPB pfet L=0.15U W=1U AS=0.135P AD=0.28P PS=1.27U
+ PD=2.56U
* device instance $430 r0 *1 108.12,1.985 pfet
M$430 Y$4 A$9 VPWR VPB pfet L=0.15U W=1U AS=0.26P AD=0.135P PS=2.52U PD=1.27U
* device instance $431 r0 *1 108.54,1.985 pfet
M$431 VPWR A$9 Y$4 VPB pfet L=0.15U W=1U AS=0.135P AD=0.26P PS=1.27U PD=2.52U
* device instance $432 r0 *1 109.68,2.065 pfet
M$432 \$158 A$24 VPWR VPB pfet L=0.15U W=0.42U AS=0.1176P AD=0.0567P PS=1.4U
+ PD=0.69U
* device instance $433 r0 *1 110.1,2.065 pfet
M$433 \$158 B$16 VPWR VPB pfet L=0.15U W=0.42U AS=0.16655P AD=0.0567P PS=1.39U
+ PD=0.69U
* device instance $434 r0 *1 110.64,1.985 pfet
M$434 X$12 \$158 VPWR VPB pfet L=0.15U W=1U AS=0.16655P AD=0.195P PS=1.39U
+ PD=1.39U
* device instance $435 r0 *1 111.18,1.985 pfet
M$435 VPWR \$158 X$12 VPB pfet L=0.15U W=1U AS=0.195P AD=0.38P PS=1.39U PD=2.76U
* device instance $436 r0 *1 120.51,1.985 pfet
M$436 Q$5 \$56 VPWR VPB pfet L=0.15U W=1U AS=0.3012P AD=0.135P PS=2.66U PD=1.27U
* device instance $437 r0 *1 120.93,1.985 pfet
M$437 VPWR \$56 Q$5 VPB pfet L=0.15U W=1U AS=0.135P AD=0.26P PS=1.27U PD=2.52U
* device instance $438 r0 *1 121.93,1.985 pfet
M$438 VPWR A$10 \$297 VPB pfet L=0.15U W=1U AS=0.28P AD=0.135P PS=2.56U PD=1.27U
* device instance $439 r0 *1 122.35,1.985 pfet
M$439 \$297 A$10 VPWR VPB pfet L=0.15U W=1U AS=0.135P AD=0.135P PS=1.27U
+ PD=1.27U
* device instance $440 r0 *1 122.77,1.985 pfet
M$440 Y$5 B$5 \$297 VPB pfet L=0.15U W=1U AS=0.135P AD=0.135P PS=1.27U PD=1.27U
* device instance $441 r0 *1 123.19,1.985 pfet
M$441 \$297 B$5 Y$5 VPB pfet L=0.15U W=1U AS=0.135P AD=0.26P PS=1.27U PD=2.52U
* device instance $442 r0 *1 132.47,1.985 pfet
M$442 Q$6 \$60 VPWR VPB pfet L=0.15U W=1U AS=0.3012P AD=0.135P PS=2.66U PD=1.27U
* device instance $443 r0 *1 132.89,1.985 pfet
M$443 VPWR \$60 Q$6 VPB pfet L=0.15U W=1U AS=0.135P AD=0.26P PS=1.27U PD=2.52U
* device instance $444 r0 *1 134.06,2.065 pfet
M$444 \$179 A$25 VPWR VPB pfet L=0.15U W=0.42U AS=0.1176P AD=0.0567P PS=1.4U
+ PD=0.69U
* device instance $445 r0 *1 134.48,2.065 pfet
M$445 \$179 B$17 VPWR VPB pfet L=0.15U W=0.42U AS=0.16655P AD=0.0567P PS=1.39U
+ PD=0.69U
* device instance $446 r0 *1 135.02,1.985 pfet
M$446 X$13 \$179 VPWR VPB pfet L=0.15U W=1U AS=0.16655P AD=0.195P PS=1.39U
+ PD=1.39U
* device instance $447 r0 *1 135.56,1.985 pfet
M$447 VPWR \$179 X$13 VPB pfet L=0.15U W=1U AS=0.195P AD=0.38P PS=1.39U PD=2.76U
* device instance $448 r0 *1 136.64,1.985 pfet
M$448 Y$6 A$11 VPWR VPB pfet L=0.15U W=1U AS=0.26P AD=0.135P PS=2.52U PD=1.27U
* device instance $449 r0 *1 137.06,1.985 pfet
M$449 VPWR A$11 Y$6 VPB pfet L=0.15U W=1U AS=0.135P AD=0.26P PS=1.27U PD=2.52U
* device instance $450 r0 *1 146.27,1.985 pfet
M$450 Q$7 \$63 VPWR VPB pfet L=0.15U W=1U AS=0.3012P AD=0.135P PS=2.66U PD=1.27U
* device instance $451 r0 *1 146.69,1.985 pfet
M$451 VPWR \$63 Q$7 VPB pfet L=0.15U W=1U AS=0.135P AD=0.26P PS=1.27U PD=2.52U
* device instance $452 r0 *1 147.86,2.065 pfet
M$452 \$192 A$26 VPWR VPB pfet L=0.15U W=0.42U AS=0.1176P AD=0.0567P PS=1.4U
+ PD=0.69U
* device instance $453 r0 *1 148.28,2.065 pfet
M$453 \$192 B$18 VPWR VPB pfet L=0.15U W=0.42U AS=0.16655P AD=0.0567P PS=1.39U
+ PD=0.69U
* device instance $454 r0 *1 148.82,1.985 pfet
M$454 X$14 \$192 VPWR VPB pfet L=0.15U W=1U AS=0.16655P AD=0.195P PS=1.39U
+ PD=1.39U
* device instance $455 r0 *1 149.36,1.985 pfet
M$455 VPWR \$192 X$14 VPB pfet L=0.15U W=1U AS=0.195P AD=0.38P PS=1.39U PD=2.76U
* device instance $456 r0 *1 156.38,1.985 pfet
M$456 VPWR \$201 \$202 VPB pfet L=0.15U W=1U AS=0.27P AD=0.135P PS=2.54U
+ PD=1.27U
* device instance $457 r0 *1 156.8,1.985 pfet
M$457 Q$8 \$202 VPWR VPB pfet L=0.15U W=1U AS=0.135P AD=0.135P PS=1.27U PD=1.27U
* device instance $458 r0 *1 157.22,1.985 pfet
M$458 VPWR \$202 Q$8 VPB pfet L=0.15U W=1U AS=0.135P AD=0.26P PS=1.27U PD=2.52U
* device instance $459 r0 *1 158.26,1.985 pfet
M$459 Y$7 A$12 VPWR VPB pfet L=0.15U W=1U AS=0.26P AD=0.135P PS=2.52U PD=1.27U
* device instance $460 r0 *1 158.68,1.985 pfet
M$460 VPWR A$12 Y$7 VPB pfet L=0.15U W=1U AS=0.135P AD=0.26P PS=1.27U PD=2.52U
* device instance $461 r0 *1 159.65,1.985 pfet
M$461 VPWR A$13 \$298 VPB pfet L=0.15U W=1U AS=0.28P AD=0.135P PS=2.56U PD=1.27U
* device instance $462 r0 *1 160.07,1.985 pfet
M$462 \$298 A$13 VPWR VPB pfet L=0.15U W=1U AS=0.135P AD=0.135P PS=1.27U
+ PD=1.27U
* device instance $463 r0 *1 160.49,1.985 pfet
M$463 Y$8 B$6 \$298 VPB pfet L=0.15U W=1U AS=0.135P AD=0.135P PS=1.27U PD=1.27U
* device instance $464 r0 *1 160.91,1.985 pfet
M$464 \$298 B$6 Y$8 VPB pfet L=0.15U W=1U AS=0.135P AD=0.26P PS=1.27U PD=2.52U
* device instance $465 r0 *1 161.95,1.985 pfet
M$465 VPWR A$14 \$299 VPB pfet L=0.15U W=1U AS=0.28P AD=0.135P PS=2.56U PD=1.27U
* device instance $466 r0 *1 162.37,1.985 pfet
M$466 \$299 A$14 VPWR VPB pfet L=0.15U W=1U AS=0.135P AD=0.135P PS=1.27U
+ PD=1.27U
* device instance $467 r0 *1 162.79,1.985 pfet
M$467 \$300 B$7 \$299 VPB pfet L=0.15U W=1U AS=0.135P AD=0.135P PS=1.27U
+ PD=1.27U
* device instance $468 r0 *1 163.21,1.985 pfet
M$468 \$299 B$7 \$300 VPB pfet L=0.15U W=1U AS=0.135P AD=0.28P PS=1.27U PD=2.56U
* device instance $469 r0 *1 164.17,1.985 pfet
M$469 Y$9 C$1 \$300 VPB pfet L=0.15U W=1U AS=0.26P AD=0.135P PS=2.52U PD=1.27U
* device instance $470 r0 *1 164.59,1.985 pfet
M$470 \$300 C$1 Y$9 VPB pfet L=0.15U W=1U AS=0.135P AD=0.26P PS=1.27U PD=2.52U
* device instance $471 r0 *1 165.63,1.985 pfet
M$471 VPWR A$15 \$301 VPB pfet L=0.15U W=1U AS=0.28P AD=0.135P PS=2.56U PD=1.27U
* device instance $472 r0 *1 166.05,1.985 pfet
M$472 \$301 A$15 VPWR VPB pfet L=0.15U W=1U AS=0.135P AD=0.135P PS=1.27U
+ PD=1.27U
* device instance $473 r0 *1 166.47,1.985 pfet
M$473 \$302 B$8 \$301 VPB pfet L=0.15U W=1U AS=0.135P AD=0.135P PS=1.27U
+ PD=1.27U
* device instance $474 r0 *1 166.89,1.985 pfet
M$474 \$301 B$8 \$302 VPB pfet L=0.15U W=1U AS=0.135P AD=0.28P PS=1.27U PD=2.56U
* device instance $475 r0 *1 167.87,1.985 pfet
M$475 \$302 C$2 \$303 VPB pfet L=0.15U W=1U AS=0.28P AD=0.135P PS=2.56U PD=1.27U
* device instance $476 r0 *1 168.29,1.985 pfet
M$476 \$303 C$2 \$302 VPB pfet L=0.15U W=1U AS=0.135P AD=0.135P PS=1.27U
+ PD=1.27U
* device instance $477 r0 *1 168.71,1.985 pfet
M$477 Y$10 D$1 \$303 VPB pfet L=0.15U W=1U AS=0.135P AD=0.135P PS=1.27U PD=1.27U
* device instance $478 r0 *1 169.13,1.985 pfet
M$478 \$303 D$1 Y$10 VPB pfet L=0.15U W=1U AS=0.135P AD=0.26P PS=1.27U PD=2.52U
* device instance $479 r0 *1 170.22,1.985 pfet
M$479 Y$11 A$16 VPWR VPB pfet L=0.15U W=1U AS=0.26P AD=0.135P PS=2.52U PD=1.27U
* device instance $480 r0 *1 170.64,1.985 pfet
M$480 VPWR A$16 Y$11 VPB pfet L=0.15U W=1U AS=0.135P AD=0.26P PS=1.27U PD=2.52U
* device instance $481 r0 *1 171.78,2.065 pfet
M$481 \$209 A$27 VPWR VPB pfet L=0.15U W=0.42U AS=0.1176P AD=0.0567P PS=1.4U
+ PD=0.69U
* device instance $482 r0 *1 172.2,2.065 pfet
M$482 \$209 B$19 VPWR VPB pfet L=0.15U W=0.42U AS=0.16655P AD=0.0567P PS=1.39U
+ PD=0.69U
* device instance $483 r0 *1 172.74,1.985 pfet
M$483 X$15 \$209 VPWR VPB pfet L=0.15U W=1U AS=0.16655P AD=0.195P PS=1.39U
+ PD=1.39U
* device instance $484 r0 *1 173.28,1.985 pfet
M$484 VPWR \$209 X$15 VPB pfet L=0.15U W=1U AS=0.195P AD=0.38P PS=1.39U PD=2.76U
* device instance $485 r0 *1 174.365,1.985 pfet
M$485 VPWR B$9 \$214 VPB pfet L=0.15U W=1U AS=0.275P AD=0.135P PS=2.55U PD=1.27U
* device instance $486 r0 *1 174.785,1.985 pfet
M$486 \$214 B$9 VPWR VPB pfet L=0.15U W=1U AS=0.135P AD=0.135P PS=1.27U PD=1.27U
* device instance $487 r0 *1 175.205,1.985 pfet
M$487 VPWR A$17 \$214 VPB pfet L=0.15U W=1U AS=0.135P AD=0.135P PS=1.27U
+ PD=1.27U
* device instance $488 r0 *1 175.625,1.985 pfet
M$488 \$214 A$17 VPWR VPB pfet L=0.15U W=1U AS=0.135P AD=0.28P PS=1.27U PD=2.56U
* device instance $489 r0 *1 176.605,1.985 pfet
M$489 VPWR A$17 \$321 VPB pfet L=0.15U W=1U AS=0.28P AD=0.135P PS=2.56U PD=1.27U
* device instance $490 r0 *1 177.025,1.985 pfet
M$490 \$321 A$17 VPWR VPB pfet L=0.15U W=1U AS=0.135P AD=0.135P PS=1.27U
+ PD=1.27U
* device instance $491 r0 *1 177.445,1.985 pfet
M$491 Y$12 B$9 \$321 VPB pfet L=0.15U W=1U AS=0.135P AD=0.1525P PS=1.27U
+ PD=1.305U
* device instance $492 r0 *1 177.9,1.985 pfet
M$492 \$321 B$9 Y$12 VPB pfet L=0.15U W=1U AS=0.1525P AD=0.26P PS=1.305U
+ PD=2.52U
* device instance $493 r0 *1 178.84,1.985 pfet
M$493 Y$12 \$214 VPWR VPB pfet L=0.15U W=1U AS=0.26P AD=0.135P PS=2.52U PD=1.27U
* device instance $494 r0 *1 179.26,1.985 pfet
M$494 VPWR \$214 Y$12 VPB pfet L=0.15U W=1U AS=0.135P AD=0.28P PS=1.27U PD=2.56U
* device instance $495 r0 *1 180.345,1.985 pfet
M$495 VPWR A$18 \$322 VPB pfet L=0.15U W=1U AS=0.275P AD=0.135P PS=2.55U
+ PD=1.27U
* device instance $496 r0 *1 180.765,1.985 pfet
M$496 \$322 A$18 VPWR VPB pfet L=0.15U W=1U AS=0.135P AD=0.135P PS=1.27U
+ PD=1.27U
* device instance $497 r0 *1 181.185,1.985 pfet
M$497 \$217 B$10 \$322 VPB pfet L=0.15U W=1U AS=0.135P AD=0.135P PS=1.27U
+ PD=1.27U
* device instance $498 r0 *1 181.605,1.985 pfet
M$498 \$322 B$10 \$217 VPB pfet L=0.15U W=1U AS=0.135P AD=0.26P PS=1.27U
+ PD=2.52U
* device instance $499 r0 *1 182.545,1.985 pfet
M$499 VPWR A$18 \$304 VPB pfet L=0.15U W=1U AS=0.26P AD=0.135P PS=2.52U PD=1.27U
* device instance $500 r0 *1 182.965,1.985 pfet
M$500 \$304 A$18 VPWR VPB pfet L=0.15U W=1U AS=0.135P AD=0.135P PS=1.27U
+ PD=1.27U
* device instance $501 r0 *1 183.385,1.985 pfet
M$501 VPWR B$10 \$304 VPB pfet L=0.15U W=1U AS=0.135P AD=0.1625P PS=1.27U
+ PD=1.325U
* device instance $502 r0 *1 183.86,1.985 pfet
M$502 \$304 B$10 VPWR VPB pfet L=0.15U W=1U AS=0.1625P AD=0.26P PS=1.325U
+ PD=2.52U
* device instance $503 r0 *1 184.8,1.985 pfet
M$503 X$16 \$217 \$304 VPB pfet L=0.15U W=1U AS=0.26P AD=0.135P PS=2.52U
+ PD=1.27U
* device instance $504 r0 *1 185.22,1.985 pfet
M$504 \$304 \$217 X$16 VPB pfet L=0.15U W=1U AS=0.135P AD=0.28P PS=1.27U
+ PD=2.56U
* device instance $505 r0 *1 186.325,1.985 pfet
M$505 VPWR A$19 \$323 VPB pfet L=0.15U W=1U AS=0.275P AD=0.135P PS=2.55U
+ PD=1.27U
* device instance $506 r0 *1 186.745,1.985 pfet
M$506 \$323 A$19 VPWR VPB pfet L=0.15U W=1U AS=0.135P AD=0.135P PS=1.27U
+ PD=1.27U
* device instance $507 r0 *1 187.165,1.985 pfet
M$507 \$220 B$11 \$323 VPB pfet L=0.15U W=1U AS=0.135P AD=0.135P PS=1.27U
+ PD=1.27U
* device instance $508 r0 *1 187.585,1.985 pfet
M$508 \$323 B$11 \$220 VPB pfet L=0.15U W=1U AS=0.135P AD=0.26P PS=1.27U
+ PD=2.52U
* device instance $509 r0 *1 188.525,1.985 pfet
M$509 VPWR A$19 \$305 VPB pfet L=0.15U W=1U AS=0.26P AD=0.135P PS=2.52U PD=1.27U
* device instance $510 r0 *1 188.945,1.985 pfet
M$510 \$305 A$19 VPWR VPB pfet L=0.15U W=1U AS=0.135P AD=0.135P PS=1.27U
+ PD=1.27U
* device instance $511 r0 *1 189.365,1.985 pfet
M$511 VPWR B$11 \$305 VPB pfet L=0.15U W=1U AS=0.135P AD=0.1625P PS=1.27U
+ PD=1.325U
* device instance $512 r0 *1 189.84,1.985 pfet
M$512 \$305 B$11 VPWR VPB pfet L=0.15U W=1U AS=0.1625P AD=0.26P PS=1.325U
+ PD=2.52U
* device instance $513 r0 *1 190.78,1.985 pfet
M$513 X$17 \$220 \$305 VPB pfet L=0.15U W=1U AS=0.26P AD=0.135P PS=2.52U
+ PD=1.27U
* device instance $514 r0 *1 191.2,1.985 pfet
M$514 \$305 \$220 X$17 VPB pfet L=0.15U W=1U AS=0.135P AD=0.28P PS=1.27U
+ PD=2.56U
* device instance $515 r0 *1 192.305,1.985 pfet
M$515 VPWR A$20 \$324 VPB pfet L=0.15U W=1U AS=0.275P AD=0.135P PS=2.55U
+ PD=1.27U
* device instance $516 r0 *1 192.725,1.985 pfet
M$516 \$324 A$20 VPWR VPB pfet L=0.15U W=1U AS=0.135P AD=0.135P PS=1.27U
+ PD=1.27U
* device instance $517 r0 *1 193.145,1.985 pfet
M$517 \$223 B$12 \$324 VPB pfet L=0.15U W=1U AS=0.135P AD=0.135P PS=1.27U
+ PD=1.27U
* device instance $518 r0 *1 193.565,1.985 pfet
M$518 \$324 B$12 \$223 VPB pfet L=0.15U W=1U AS=0.135P AD=0.26P PS=1.27U
+ PD=2.52U
* device instance $519 r0 *1 194.505,1.985 pfet
M$519 VPWR A$20 \$306 VPB pfet L=0.15U W=1U AS=0.26P AD=0.135P PS=2.52U PD=1.27U
* device instance $520 r0 *1 194.925,1.985 pfet
M$520 \$306 A$20 VPWR VPB pfet L=0.15U W=1U AS=0.135P AD=0.135P PS=1.27U
+ PD=1.27U
* device instance $521 r0 *1 195.345,1.985 pfet
M$521 VPWR B$12 \$306 VPB pfet L=0.15U W=1U AS=0.135P AD=0.1625P PS=1.27U
+ PD=1.325U
* device instance $522 r0 *1 195.82,1.985 pfet
M$522 \$306 B$12 VPWR VPB pfet L=0.15U W=1U AS=0.1625P AD=0.26P PS=1.325U
+ PD=2.52U
* device instance $523 r0 *1 196.76,1.985 pfet
M$523 X$18 \$223 \$306 VPB pfet L=0.15U W=1U AS=0.26P AD=0.135P PS=2.52U
+ PD=1.27U
* device instance $524 r0 *1 197.18,1.985 pfet
M$524 \$306 \$223 X$18 VPB pfet L=0.15U W=1U AS=0.135P AD=0.28P PS=1.27U
+ PD=2.56U
* device instance $525 r0 *1 198.285,1.985 pfet
M$525 VPWR A$21 \$325 VPB pfet L=0.15U W=1U AS=0.275P AD=0.135P PS=2.55U
+ PD=1.27U
* device instance $526 r0 *1 198.705,1.985 pfet
M$526 \$325 A$21 VPWR VPB pfet L=0.15U W=1U AS=0.135P AD=0.135P PS=1.27U
+ PD=1.27U
* device instance $527 r0 *1 199.125,1.985 pfet
M$527 \$226 B$13 \$325 VPB pfet L=0.15U W=1U AS=0.135P AD=0.135P PS=1.27U
+ PD=1.27U
* device instance $528 r0 *1 199.545,1.985 pfet
M$528 \$325 B$13 \$226 VPB pfet L=0.15U W=1U AS=0.135P AD=0.26P PS=1.27U
+ PD=2.52U
* device instance $529 r0 *1 200.485,1.985 pfet
M$529 VPWR A$21 \$307 VPB pfet L=0.15U W=1U AS=0.26P AD=0.135P PS=2.52U PD=1.27U
* device instance $530 r0 *1 200.905,1.985 pfet
M$530 \$307 A$21 VPWR VPB pfet L=0.15U W=1U AS=0.135P AD=0.135P PS=1.27U
+ PD=1.27U
* device instance $531 r0 *1 201.325,1.985 pfet
M$531 VPWR B$13 \$307 VPB pfet L=0.15U W=1U AS=0.135P AD=0.1625P PS=1.27U
+ PD=1.325U
* device instance $532 r0 *1 201.8,1.985 pfet
M$532 \$307 B$13 VPWR VPB pfet L=0.15U W=1U AS=0.1625P AD=0.26P PS=1.325U
+ PD=2.52U
* device instance $533 r0 *1 202.74,1.985 pfet
M$533 X$19 \$226 \$307 VPB pfet L=0.15U W=1U AS=0.26P AD=0.135P PS=2.52U
+ PD=1.27U
* device instance $534 r0 *1 203.16,1.985 pfet
M$534 \$307 \$226 X$19 VPB pfet L=0.15U W=1U AS=0.135P AD=0.28P PS=1.27U
+ PD=2.56U
* device instance $535 r0 *1 0.47,2.135 pfet
M$535 VPWR CLK \$87 VPB pfet L=0.15U W=0.64U AS=0.1664P AD=0.0864P PS=1.8U
+ PD=0.91U
* device instance $536 r0 *1 0.89,2.135 pfet
M$536 \$88 \$87 VPWR VPB pfet L=0.15U W=0.64U AS=0.0864P AD=0.1664P PS=0.91U
+ PD=1.8U
* device instance $537 r0 *1 2.225,2.275 pfet
M$537 \$89 D$2 VPWR VPB pfet L=0.15U W=0.42U AS=0.1092P AD=0.0651P PS=1.36U
+ PD=0.73U
* device instance $538 r0 *1 2.685,2.275 pfet
M$538 \$90 \$88 \$89 VPB pfet L=0.15U W=0.42U AS=0.0651P AD=0.07245P PS=0.73U
+ PD=0.765U
* device instance $539 r0 *1 3.18,2.275 pfet
M$539 \$309 \$87 \$90 VPB pfet L=0.15U W=0.42U AS=0.07245P AD=0.1155P PS=0.765U
+ PD=0.97U
* device instance $540 r0 *1 3.88,2.275 pfet
M$540 VPWR \$2 \$309 VPB pfet L=0.15U W=0.42U AS=0.1155P AD=0.07035P PS=0.97U
+ PD=0.755U
* device instance $541 r0 *1 4.365,2.275 pfet
M$541 \$309 RESET_B VPWR VPB pfet L=0.15U W=0.42U AS=0.07035P AD=0.1092P
+ PS=0.755U PD=1.36U
* device instance $542 r0 *1 5.35,2.065 pfet
M$542 \$2 \$90 VPWR VPB pfet L=0.15U W=0.84U AS=0.2184P AD=0.12915P PS=2.2U
+ PD=1.185U
* device instance $543 r0 *1 5.845,2.275 pfet
M$543 \$92 \$87 \$2 VPB pfet L=0.15U W=0.42U AS=0.12915P AD=0.0588P PS=1.185U
+ PD=0.7U
* device instance $544 r0 *1 6.275,2.275 pfet
M$544 \$326 \$88 \$92 VPB pfet L=0.15U W=0.42U AS=0.0588P AD=0.0567P PS=0.7U
+ PD=0.69U
* device instance $545 r0 *1 6.695,2.275 pfet
M$545 VPWR \$3 \$326 VPB pfet L=0.15U W=0.42U AS=0.0567P AD=0.0819P PS=0.69U
+ PD=0.81U
* device instance $546 r0 *1 7.235,2.275 pfet
M$546 \$3 RESET_B VPWR VPB pfet L=0.15U W=0.42U AS=0.0819P AD=0.0567P PS=0.81U
+ PD=0.69U
* device instance $547 r0 *1 7.655,2.275 pfet
M$547 VPWR \$92 \$3 VPB pfet L=0.15U W=0.42U AS=0.0567P AD=0.1134P PS=0.69U
+ PD=1.38U
* device instance $548 r0 *1 15.65,2.135 pfet
M$548 VPWR CLK$1 \$97 VPB pfet L=0.15U W=0.64U AS=0.1664P AD=0.0864P PS=1.8U
+ PD=0.91U
* device instance $549 r0 *1 16.07,2.135 pfet
M$549 \$98 \$97 VPWR VPB pfet L=0.15U W=0.64U AS=0.0864P AD=0.1664P PS=0.91U
+ PD=1.8U
* device instance $550 r0 *1 17.405,2.275 pfet
M$550 \$99 D$3 VPWR VPB pfet L=0.15U W=0.42U AS=0.1092P AD=0.0651P PS=1.36U
+ PD=0.73U
* device instance $551 r0 *1 17.865,2.275 pfet
M$551 \$100 \$98 \$99 VPB pfet L=0.15U W=0.42U AS=0.0651P AD=0.07245P PS=0.73U
+ PD=0.765U
* device instance $552 r0 *1 18.36,2.275 pfet
M$552 \$310 \$97 \$100 VPB pfet L=0.15U W=0.42U AS=0.07245P AD=0.1155P
+ PS=0.765U PD=0.97U
* device instance $553 r0 *1 19.06,2.275 pfet
M$553 VPWR \$10 \$310 VPB pfet L=0.15U W=0.42U AS=0.1155P AD=0.07035P PS=0.97U
+ PD=0.755U
* device instance $554 r0 *1 19.545,2.275 pfet
M$554 \$310 RESET_B$1 VPWR VPB pfet L=0.15U W=0.42U AS=0.07035P AD=0.1092P
+ PS=0.755U PD=1.36U
* device instance $555 r0 *1 20.53,2.065 pfet
M$555 \$10 \$100 VPWR VPB pfet L=0.15U W=0.84U AS=0.2184P AD=0.12915P PS=2.2U
+ PD=1.185U
* device instance $556 r0 *1 21.025,2.275 pfet
M$556 \$102 \$97 \$10 VPB pfet L=0.15U W=0.42U AS=0.12915P AD=0.0588P PS=1.185U
+ PD=0.7U
* device instance $557 r0 *1 21.455,2.275 pfet
M$557 \$329 \$98 \$102 VPB pfet L=0.15U W=0.42U AS=0.0588P AD=0.0567P PS=0.7U
+ PD=0.69U
* device instance $558 r0 *1 21.875,2.275 pfet
M$558 VPWR \$11 \$329 VPB pfet L=0.15U W=0.42U AS=0.0567P AD=0.0819P PS=0.69U
+ PD=0.81U
* device instance $559 r0 *1 22.415,2.275 pfet
M$559 \$11 RESET_B$1 VPWR VPB pfet L=0.15U W=0.42U AS=0.0819P AD=0.0567P
+ PS=0.81U PD=0.69U
* device instance $560 r0 *1 22.835,2.275 pfet
M$560 VPWR \$102 \$11 VPB pfet L=0.15U W=0.42U AS=0.0567P AD=0.1134P PS=0.69U
+ PD=1.38U
* device instance $561 r0 *1 36.81,2.135 pfet
M$561 VPWR CLK$2 \$110 VPB pfet L=0.15U W=0.64U AS=0.1664P AD=0.0864P PS=1.8U
+ PD=0.91U
* device instance $562 r0 *1 37.23,2.135 pfet
M$562 \$111 \$110 VPWR VPB pfet L=0.15U W=0.64U AS=0.0864P AD=0.1664P PS=0.91U
+ PD=1.8U
* device instance $563 r0 *1 38.565,2.275 pfet
M$563 \$112 D$4 VPWR VPB pfet L=0.15U W=0.42U AS=0.1092P AD=0.0651P PS=1.36U
+ PD=0.73U
* device instance $564 r0 *1 39.025,2.275 pfet
M$564 \$113 \$111 \$112 VPB pfet L=0.15U W=0.42U AS=0.0651P AD=0.07245P
+ PS=0.73U PD=0.765U
* device instance $565 r0 *1 39.52,2.275 pfet
M$565 \$312 \$110 \$113 VPB pfet L=0.15U W=0.42U AS=0.07245P AD=0.1155P
+ PS=0.765U PD=0.97U
* device instance $566 r0 *1 40.22,2.275 pfet
M$566 VPWR \$20 \$312 VPB pfet L=0.15U W=0.42U AS=0.1155P AD=0.07035P PS=0.97U
+ PD=0.755U
* device instance $567 r0 *1 40.705,2.275 pfet
M$567 \$312 RESET_B$2 VPWR VPB pfet L=0.15U W=0.42U AS=0.07035P AD=0.1092P
+ PS=0.755U PD=1.36U
* device instance $568 r0 *1 41.69,2.065 pfet
M$568 \$20 \$113 VPWR VPB pfet L=0.15U W=0.84U AS=0.2184P AD=0.12915P PS=2.2U
+ PD=1.185U
* device instance $569 r0 *1 42.185,2.275 pfet
M$569 \$115 \$110 \$20 VPB pfet L=0.15U W=0.42U AS=0.12915P AD=0.0588P
+ PS=1.185U PD=0.7U
* device instance $570 r0 *1 42.615,2.275 pfet
M$570 \$332 \$111 \$115 VPB pfet L=0.15U W=0.42U AS=0.0588P AD=0.0567P PS=0.7U
+ PD=0.69U
* device instance $571 r0 *1 43.035,2.275 pfet
M$571 VPWR \$21 \$332 VPB pfet L=0.15U W=0.42U AS=0.0567P AD=0.0819P PS=0.69U
+ PD=0.81U
* device instance $572 r0 *1 43.575,2.275 pfet
M$572 \$21 RESET_B$2 VPWR VPB pfet L=0.15U W=0.42U AS=0.0819P AD=0.0567P
+ PS=0.81U PD=0.69U
* device instance $573 r0 *1 43.995,2.275 pfet
M$573 VPWR \$115 \$21 VPB pfet L=0.15U W=0.42U AS=0.0567P AD=0.1134P PS=0.69U
+ PD=1.38U
* device instance $574 r0 *1 60.73,2.135 pfet
M$574 VPWR CLK$3 \$127 VPB pfet L=0.15U W=0.64U AS=0.1664P AD=0.0864P PS=1.8U
+ PD=0.91U
* device instance $575 r0 *1 61.15,2.135 pfet
M$575 \$128 \$127 VPWR VPB pfet L=0.15U W=0.64U AS=0.0864P AD=0.1664P PS=0.91U
+ PD=1.8U
* device instance $576 r0 *1 62.485,2.275 pfet
M$576 \$129 D$5 VPWR VPB pfet L=0.15U W=0.42U AS=0.1092P AD=0.0651P PS=1.36U
+ PD=0.73U
* device instance $577 r0 *1 62.945,2.275 pfet
M$577 \$130 \$128 \$129 VPB pfet L=0.15U W=0.42U AS=0.0651P AD=0.07245P
+ PS=0.73U PD=0.765U
* device instance $578 r0 *1 63.44,2.275 pfet
M$578 \$314 \$127 \$130 VPB pfet L=0.15U W=0.42U AS=0.07245P AD=0.1155P
+ PS=0.765U PD=0.97U
* device instance $579 r0 *1 64.14,2.275 pfet
M$579 VPWR \$30 \$314 VPB pfet L=0.15U W=0.42U AS=0.1155P AD=0.07035P PS=0.97U
+ PD=0.755U
* device instance $580 r0 *1 64.625,2.275 pfet
M$580 \$314 RESET_B$3 VPWR VPB pfet L=0.15U W=0.42U AS=0.07035P AD=0.1092P
+ PS=0.755U PD=1.36U
* device instance $581 r0 *1 65.61,2.065 pfet
M$581 \$30 \$130 VPWR VPB pfet L=0.15U W=0.84U AS=0.2184P AD=0.12915P PS=2.2U
+ PD=1.185U
* device instance $582 r0 *1 66.105,2.275 pfet
M$582 \$132 \$127 \$30 VPB pfet L=0.15U W=0.42U AS=0.12915P AD=0.0588P
+ PS=1.185U PD=0.7U
* device instance $583 r0 *1 66.535,2.275 pfet
M$583 \$335 \$128 \$132 VPB pfet L=0.15U W=0.42U AS=0.0588P AD=0.0567P PS=0.7U
+ PD=0.69U
* device instance $584 r0 *1 66.955,2.275 pfet
M$584 VPWR \$31 \$335 VPB pfet L=0.15U W=0.42U AS=0.0567P AD=0.0819P PS=0.69U
+ PD=0.81U
* device instance $585 r0 *1 67.495,2.275 pfet
M$585 \$31 RESET_B$3 VPWR VPB pfet L=0.15U W=0.42U AS=0.0819P AD=0.0567P
+ PS=0.81U PD=0.69U
* device instance $586 r0 *1 67.915,2.275 pfet
M$586 VPWR \$132 \$31 VPB pfet L=0.15U W=0.42U AS=0.0567P AD=0.1134P PS=0.69U
+ PD=1.38U
* device instance $587 r0 *1 84.65,2.135 pfet
M$587 VPWR CLK$4 \$145 VPB pfet L=0.15U W=0.64U AS=0.1664P AD=0.0864P PS=1.8U
+ PD=0.91U
* device instance $588 r0 *1 85.07,2.135 pfet
M$588 \$146 \$145 VPWR VPB pfet L=0.15U W=0.64U AS=0.0864P AD=0.1664P PS=0.91U
+ PD=1.8U
* device instance $589 r0 *1 86.405,2.275 pfet
M$589 \$147 D$6 VPWR VPB pfet L=0.15U W=0.42U AS=0.1092P AD=0.0651P PS=1.36U
+ PD=0.73U
* device instance $590 r0 *1 86.865,2.275 pfet
M$590 \$148 \$146 \$147 VPB pfet L=0.15U W=0.42U AS=0.0651P AD=0.07245P
+ PS=0.73U PD=0.765U
* device instance $591 r0 *1 87.36,2.275 pfet
M$591 \$316 \$145 \$148 VPB pfet L=0.15U W=0.42U AS=0.07245P AD=0.1155P
+ PS=0.765U PD=0.97U
* device instance $592 r0 *1 88.06,2.275 pfet
M$592 VPWR \$40 \$316 VPB pfet L=0.15U W=0.42U AS=0.1155P AD=0.07035P PS=0.97U
+ PD=0.755U
* device instance $593 r0 *1 88.545,2.275 pfet
M$593 \$316 RESET_B$4 VPWR VPB pfet L=0.15U W=0.42U AS=0.07035P AD=0.1092P
+ PS=0.755U PD=1.36U
* device instance $594 r0 *1 89.53,2.065 pfet
M$594 \$40 \$148 VPWR VPB pfet L=0.15U W=0.84U AS=0.2184P AD=0.12915P PS=2.2U
+ PD=1.185U
* device instance $595 r0 *1 90.025,2.275 pfet
M$595 \$150 \$145 \$40 VPB pfet L=0.15U W=0.42U AS=0.12915P AD=0.0588P
+ PS=1.185U PD=0.7U
* device instance $596 r0 *1 90.455,2.275 pfet
M$596 \$338 \$146 \$150 VPB pfet L=0.15U W=0.42U AS=0.0588P AD=0.0567P PS=0.7U
+ PD=0.69U
* device instance $597 r0 *1 90.875,2.275 pfet
M$597 VPWR \$41 \$338 VPB pfet L=0.15U W=0.42U AS=0.0567P AD=0.0819P PS=0.69U
+ PD=0.81U
* device instance $598 r0 *1 91.415,2.275 pfet
M$598 \$41 RESET_B$4 VPWR VPB pfet L=0.15U W=0.42U AS=0.0819P AD=0.0567P
+ PS=0.81U PD=0.69U
* device instance $599 r0 *1 91.835,2.275 pfet
M$599 VPWR \$150 \$41 VPB pfet L=0.15U W=0.42U AS=0.0567P AD=0.1134P PS=0.69U
+ PD=1.38U
* device instance $600 r0 *1 104.43,2.275 pfet
M$600 \$53 A$8 VPWR VPB pfet L=0.15U W=0.42U AS=0.1092P AD=0.07455P PS=1.36U
+ PD=0.775U
* device instance $601 r0 *1 104.935,2.275 pfet
M$601 VPWR B$4 \$53 VPB pfet L=0.15U W=0.42U AS=0.07455P AD=0.0777P PS=0.775U
+ PD=0.79U
* device instance $602 r0 *1 105.455,2.275 pfet
M$602 \$53 C VPWR VPB pfet L=0.15U W=0.42U AS=0.0777P AD=0.0588P PS=0.79U
+ PD=0.7U
* device instance $603 r0 *1 105.885,2.275 pfet
M$603 \$53 D VPWR VPB pfet L=0.15U W=0.42U AS=0.27995P AD=0.0588P PS=1.615U
+ PD=0.7U
* device instance $604 r0 *1 106.65,1.985 pfet
M$604 X$11 \$53 VPWR VPB pfet L=0.15U W=1U AS=0.27995P AD=0.165P PS=1.615U
+ PD=1.33U
* device instance $605 r0 *1 107.13,1.985 pfet
M$605 VPWR \$53 X$11 VPB pfet L=0.15U W=1U AS=0.165P AD=0.3P PS=1.33U PD=2.6U
* device instance $606 r0 *1 112.25,2.135 pfet
M$606 VPWR CLK$5 \$163 VPB pfet L=0.15U W=0.64U AS=0.1664P AD=0.0864P PS=1.8U
+ PD=0.91U
* device instance $607 r0 *1 112.67,2.135 pfet
M$607 \$164 \$163 VPWR VPB pfet L=0.15U W=0.64U AS=0.0864P AD=0.1664P PS=0.91U
+ PD=1.8U
* device instance $608 r0 *1 114.005,2.275 pfet
M$608 \$165 D$7 VPWR VPB pfet L=0.15U W=0.42U AS=0.1092P AD=0.0651P PS=1.36U
+ PD=0.73U
* device instance $609 r0 *1 114.465,2.275 pfet
M$609 \$166 \$164 \$165 VPB pfet L=0.15U W=0.42U AS=0.0651P AD=0.07245P
+ PS=0.73U PD=0.765U
* device instance $610 r0 *1 114.96,2.275 pfet
M$610 \$318 \$163 \$166 VPB pfet L=0.15U W=0.42U AS=0.07245P AD=0.1155P
+ PS=0.765U PD=0.97U
* device instance $611 r0 *1 115.66,2.275 pfet
M$611 VPWR \$55 \$318 VPB pfet L=0.15U W=0.42U AS=0.1155P AD=0.07035P PS=0.97U
+ PD=0.755U
* device instance $612 r0 *1 116.145,2.275 pfet
M$612 \$318 RESET_B$5 VPWR VPB pfet L=0.15U W=0.42U AS=0.07035P AD=0.1092P
+ PS=0.755U PD=1.36U
* device instance $613 r0 *1 117.13,2.065 pfet
M$613 \$55 \$166 VPWR VPB pfet L=0.15U W=0.84U AS=0.2184P AD=0.12915P PS=2.2U
+ PD=1.185U
* device instance $614 r0 *1 117.625,2.275 pfet
M$614 \$168 \$163 \$55 VPB pfet L=0.15U W=0.42U AS=0.12915P AD=0.0588P
+ PS=1.185U PD=0.7U
* device instance $615 r0 *1 118.055,2.275 pfet
M$615 \$341 \$164 \$168 VPB pfet L=0.15U W=0.42U AS=0.0588P AD=0.0567P PS=0.7U
+ PD=0.69U
* device instance $616 r0 *1 118.475,2.275 pfet
M$616 VPWR \$56 \$341 VPB pfet L=0.15U W=0.42U AS=0.0567P AD=0.0819P PS=0.69U
+ PD=0.81U
* device instance $617 r0 *1 119.015,2.275 pfet
M$617 \$56 RESET_B$5 VPWR VPB pfet L=0.15U W=0.42U AS=0.0819P AD=0.0567P
+ PS=0.81U PD=0.69U
* device instance $618 r0 *1 119.435,2.275 pfet
M$618 VPWR \$168 \$56 VPB pfet L=0.15U W=0.42U AS=0.0567P AD=0.1134P PS=0.69U
+ PD=1.38U
* device instance $619 r0 *1 124.21,2.135 pfet
M$619 VPWR CLK$6 \$172 VPB pfet L=0.15U W=0.64U AS=0.1664P AD=0.0864P PS=1.8U
+ PD=0.91U
* device instance $620 r0 *1 124.63,2.135 pfet
M$620 \$173 \$172 VPWR VPB pfet L=0.15U W=0.64U AS=0.0864P AD=0.1664P PS=0.91U
+ PD=1.8U
* device instance $621 r0 *1 125.965,2.275 pfet
M$621 \$174 D$8 VPWR VPB pfet L=0.15U W=0.42U AS=0.1092P AD=0.0651P PS=1.36U
+ PD=0.73U
* device instance $622 r0 *1 126.425,2.275 pfet
M$622 \$175 \$173 \$174 VPB pfet L=0.15U W=0.42U AS=0.0651P AD=0.07245P
+ PS=0.73U PD=0.765U
* device instance $623 r0 *1 126.92,2.275 pfet
M$623 \$319 \$172 \$175 VPB pfet L=0.15U W=0.42U AS=0.07245P AD=0.1155P
+ PS=0.765U PD=0.97U
* device instance $624 r0 *1 127.62,2.275 pfet
M$624 VPWR \$59 \$319 VPB pfet L=0.15U W=0.42U AS=0.1155P AD=0.07035P PS=0.97U
+ PD=0.755U
* device instance $625 r0 *1 128.105,2.275 pfet
M$625 \$319 RESET_B$6 VPWR VPB pfet L=0.15U W=0.42U AS=0.07035P AD=0.1092P
+ PS=0.755U PD=1.36U
* device instance $626 r0 *1 129.09,2.065 pfet
M$626 \$59 \$175 VPWR VPB pfet L=0.15U W=0.84U AS=0.2184P AD=0.12915P PS=2.2U
+ PD=1.185U
* device instance $627 r0 *1 129.585,2.275 pfet
M$627 \$177 \$172 \$59 VPB pfet L=0.15U W=0.42U AS=0.12915P AD=0.0588P
+ PS=1.185U PD=0.7U
* device instance $628 r0 *1 130.015,2.275 pfet
M$628 \$342 \$173 \$177 VPB pfet L=0.15U W=0.42U AS=0.0588P AD=0.0567P PS=0.7U
+ PD=0.69U
* device instance $629 r0 *1 130.435,2.275 pfet
M$629 VPWR \$60 \$342 VPB pfet L=0.15U W=0.42U AS=0.0567P AD=0.0819P PS=0.69U
+ PD=0.81U
* device instance $630 r0 *1 130.975,2.275 pfet
M$630 \$60 RESET_B$6 VPWR VPB pfet L=0.15U W=0.42U AS=0.0819P AD=0.0567P
+ PS=0.81U PD=0.69U
* device instance $631 r0 *1 131.395,2.275 pfet
M$631 VPWR \$177 \$60 VPB pfet L=0.15U W=0.42U AS=0.0567P AD=0.1134P PS=0.69U
+ PD=1.38U
* device instance $632 r0 *1 138.01,2.135 pfet
M$632 VPWR CLK$7 \$185 VPB pfet L=0.15U W=0.64U AS=0.1664P AD=0.0864P PS=1.8U
+ PD=0.91U
* device instance $633 r0 *1 138.43,2.135 pfet
M$633 \$186 \$185 VPWR VPB pfet L=0.15U W=0.64U AS=0.0864P AD=0.1664P PS=0.91U
+ PD=1.8U
* device instance $634 r0 *1 139.765,2.275 pfet
M$634 \$187 D$9 VPWR VPB pfet L=0.15U W=0.42U AS=0.1092P AD=0.0651P PS=1.36U
+ PD=0.73U
* device instance $635 r0 *1 140.225,2.275 pfet
M$635 \$188 \$186 \$187 VPB pfet L=0.15U W=0.42U AS=0.0651P AD=0.07245P
+ PS=0.73U PD=0.765U
* device instance $636 r0 *1 140.72,2.275 pfet
M$636 \$320 \$185 \$188 VPB pfet L=0.15U W=0.42U AS=0.07245P AD=0.1155P
+ PS=0.765U PD=0.97U
* device instance $637 r0 *1 141.42,2.275 pfet
M$637 VPWR \$62 \$320 VPB pfet L=0.15U W=0.42U AS=0.1155P AD=0.07035P PS=0.97U
+ PD=0.755U
* device instance $638 r0 *1 141.905,2.275 pfet
M$638 \$320 RESET_B$7 VPWR VPB pfet L=0.15U W=0.42U AS=0.07035P AD=0.1092P
+ PS=0.755U PD=1.36U
* device instance $639 r0 *1 142.89,2.065 pfet
M$639 \$62 \$188 VPWR VPB pfet L=0.15U W=0.84U AS=0.2184P AD=0.12915P PS=2.2U
+ PD=1.185U
* device instance $640 r0 *1 143.385,2.275 pfet
M$640 \$190 \$185 \$62 VPB pfet L=0.15U W=0.42U AS=0.12915P AD=0.0588P
+ PS=1.185U PD=0.7U
* device instance $641 r0 *1 143.815,2.275 pfet
M$641 \$343 \$186 \$190 VPB pfet L=0.15U W=0.42U AS=0.0588P AD=0.0567P PS=0.7U
+ PD=0.69U
* device instance $642 r0 *1 144.235,2.275 pfet
M$642 VPWR \$63 \$343 VPB pfet L=0.15U W=0.42U AS=0.0567P AD=0.0819P PS=0.69U
+ PD=0.81U
* device instance $643 r0 *1 144.775,2.275 pfet
M$643 \$63 RESET_B$7 VPWR VPB pfet L=0.15U W=0.42U AS=0.0819P AD=0.0567P
+ PS=0.81U PD=0.69U
* device instance $644 r0 *1 145.195,2.275 pfet
M$644 VPWR \$190 \$63 VPB pfet L=0.15U W=0.42U AS=0.0567P AD=0.1134P PS=0.69U
+ PD=1.38U
* device instance $645 r0 *1 150.43,2.135 pfet
M$645 VPWR CLK$8 \$197 VPB pfet L=0.15U W=0.64U AS=0.1664P AD=0.0864P PS=1.8U
+ PD=0.91U
* device instance $646 r0 *1 150.85,2.135 pfet
M$646 \$198 \$197 VPWR VPB pfet L=0.15U W=0.64U AS=0.0864P AD=0.1664P PS=0.91U
+ PD=1.8U
* device instance $647 r0 *1 151.79,2.275 pfet
M$647 \$199 D$10 VPWR VPB pfet L=0.15U W=0.42U AS=0.1092P AD=0.05775P PS=1.36U
+ PD=0.695U
* device instance $648 r0 *1 152.215,2.275 pfet
M$648 \$200 \$198 \$199 VPB pfet L=0.15U W=0.42U AS=0.05775P AD=0.06825P
+ PS=0.695U PD=0.745U
* device instance $649 r0 *1 152.69,2.275 pfet
M$649 \$344 \$197 \$200 VPB pfet L=0.15U W=0.42U AS=0.06825P AD=0.07665P
+ PS=0.745U PD=0.785U
* device instance $650 r0 *1 153.205,2.275 pfet
M$650 \$344 \$64 VPWR VPB pfet L=0.15U W=0.42U AS=0.178875P AD=0.07665P
+ PS=1.26U PD=0.785U
* device instance $651 r0 *1 153.865,2.11 pfet
M$651 \$64 \$200 VPWR VPB pfet L=0.15U W=0.75U AS=0.178875P AD=0.1095P PS=1.26U
+ PD=1.075U
* device instance $652 r0 *1 154.34,2.275 pfet
M$652 \$201 \$197 \$64 VPB pfet L=0.15U W=0.42U AS=0.1095P AD=0.0567P PS=1.075U
+ PD=0.69U
* device instance $653 r0 *1 154.76,2.275 pfet
M$653 \$345 \$198 \$201 VPB pfet L=0.15U W=0.42U AS=0.0567P AD=0.0882P PS=0.69U
+ PD=0.84U
* device instance $654 r0 *1 155.33,2.275 pfet
M$654 VPWR \$202 \$345 VPB pfet L=0.15U W=0.42U AS=0.0882P AD=0.1113P PS=0.84U
+ PD=1.37U
.ENDS pll_divider_intN
