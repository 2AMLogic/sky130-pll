* extracted by klt extract --deck sky130

* cell pll_vco_ring5
* pin vsubs
.SUBCKT pll_vco_ring5 vsubs
* device instance $1 r0 *1 0.495,1 nfet
M$1 \$18 \$1 \$15 vsubs nfet L=0.15U W=2U AS=0.84P AD=0.84P PS=4.84U PD=4.84U
* device instance $2 r0 *1 1.885,1 nfet
M$2 \$23 \$2 \$21 vsubs nfet L=0.15U W=2U AS=0.84P AD=0.84P PS=4.84U PD=4.84U
* device instance $3 r0 *1 3.275,1 nfet
M$3 \$29 \$3 \$26 vsubs nfet L=0.15U W=2U AS=0.84P AD=0.84P PS=4.84U PD=4.84U
* device instance $4 r0 *1 8.44,1 nfet
M$4 \$33 \$4 \$30 vsubs nfet L=0.5U W=2U AS=0.84P AD=0.84P PS=4.84U PD=4.84U
* device instance $5 r0 *1 10.18,1 nfet
M$5 \$39 \$5 \$35 vsubs nfet L=0.5U W=2U AS=0.84P AD=0.84P PS=4.84U PD=4.84U
* device instance $6 r0 *1 11.92,1 nfet
M$6 \$43 \$6 \$41 vsubs nfet L=0.5U W=2U AS=0.84P AD=0.84P PS=4.84U PD=4.84U
* device instance $7 r0 *1 0.495,3.82 nfet
M$7 \$19 \$17 \$16 vsubs nfet L=0.15U W=2U AS=0.84P AD=0.84P PS=4.84U PD=4.84U
* device instance $8 r0 *1 1.885,3.82 nfet
M$8 \$24 \$22 \$20 vsubs nfet L=0.15U W=2U AS=0.84P AD=0.84P PS=4.84U PD=4.84U
* device instance $9 r0 *1 3.275,3.82 nfet
M$9 \$28 \$27 \$25 vsubs nfet L=0.15U W=2U AS=0.84P AD=0.84P PS=4.84U PD=4.84U
* device instance $10 r0 *1 8.44,3.82 nfet
M$10 \$34 \$32 \$31 vsubs nfet L=0.5U W=2U AS=0.84P AD=0.84P PS=4.84U PD=4.84U
* device instance $11 r0 *1 10.18,3.82 nfet
M$11 \$38 \$37 \$36 vsubs nfet L=0.5U W=2U AS=0.84P AD=0.84P PS=4.84U PD=4.84U
* device instance $12 r0 *1 11.92,3.82 nfet
M$12 \$44 \$42 \$40 vsubs nfet L=0.5U W=2U AS=0.84P AD=0.84P PS=4.84U PD=4.84U
* device instance $13 r0 *1 17.085,4 nfet
M$13 \$46 \$7 \$45 vsubs nfet L=0.15U W=8U AS=3.36P AD=3.36P PS=16.84U PD=16.84U
* device instance $14 r0 *1 22.075,2 pfet
M$14 \$49 \$8 \$47 \$79 pfet L=0.15U W=4U AS=1.68P AD=1.68P PS=8.84U PD=8.84U
* device instance $15 r0 *1 23.465,2 pfet
M$15 \$52 \$9 \$50 \$79 pfet L=0.15U W=4U AS=1.68P AD=1.68P PS=8.84U PD=8.84U
* device instance $16 r0 *1 24.855,2 pfet
M$16 \$55 \$10 \$53 \$79 pfet L=0.15U W=4U AS=1.68P AD=1.68P PS=8.84U PD=8.84U
* device instance $17 r0 *1 30.32,2 pfet
M$17 \$58 \$11 \$56 \$80 pfet L=0.5U W=4U AS=1.68P AD=1.68P PS=8.84U PD=8.84U
* device instance $18 r0 *1 32.06,2 pfet
M$18 \$61 \$12 \$59 \$80 pfet L=0.5U W=4U AS=1.68P AD=1.68P PS=8.84U PD=8.84U
* device instance $19 r0 *1 33.8,2 pfet
M$19 \$64 \$13 \$62 \$80 pfet L=0.5U W=4U AS=1.68P AD=1.68P PS=8.84U PD=8.84U
* device instance $20 r0 *1 22.075,6.82 pfet
M$20 \$66 \$48 \$65 \$79 pfet L=0.15U W=4U AS=1.68P AD=1.68P PS=8.84U PD=8.84U
* device instance $21 r0 *1 23.465,6.82 pfet
M$21 \$68 \$51 \$67 \$79 pfet L=0.15U W=4U AS=1.68P AD=1.68P PS=8.84U PD=8.84U
* device instance $22 r0 *1 24.855,6.82 pfet
M$22 \$70 \$54 \$69 \$79 pfet L=0.15U W=4U AS=1.68P AD=1.68P PS=8.84U PD=8.84U
* device instance $23 r0 *1 30.32,6.82 pfet
M$23 \$72 \$57 \$71 \$80 pfet L=0.5U W=4U AS=1.68P AD=1.68P PS=8.84U PD=8.84U
* device instance $24 r0 *1 32.06,6.82 pfet
M$24 \$74 \$60 \$73 \$80 pfet L=0.5U W=4U AS=1.68P AD=1.68P PS=8.84U PD=8.84U
* device instance $25 r0 *1 33.8,6.82 pfet
M$25 \$76 \$63 \$75 \$80 pfet L=0.5U W=4U AS=1.68P AD=1.68P PS=8.84U PD=8.84U
* device instance $26 r0 *1 39.265,8 pfet
M$26 \$78 \$14 \$77 \$81 pfet L=0.15U W=16U AS=6.72P AD=6.72P PS=32.84U
+ PD=32.84U
.ENDS pll_vco_ring5
