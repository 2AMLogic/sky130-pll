* extracted by klt extract --deck sky130

* cell pll_loop_filter
* pin vsubs
.SUBCKT pll_loop_filter vsubs
* device instance $1 r0 *1 106.68,81.7 sky130_fd_pr__model__cap_mim
C$1 \$5 \$8 5.326188e-11 sky130_fd_pr__model__cap_mim
* device instance $2 r0 *1 17.7,185.1 sky130_fd_pr__model__cap_mim
C$2 \$6 \$9 2.4766e-12 sky130_fd_pr__model__cap_mim
* device instance $3 r0 *1 60.6,188.6 sky130_fd_pr__model__cap_mim
C$3 \$7 \$10 3.55992e-12 sky130_fd_pr__model__cap_mim
* device instance $4 r0 *1 2.92,0.5 res_xhigh_po
R$4 \$1 \$2 vsubs 10000 res_xhigh_po
* device instance $5 r0 *1 15.41,0.5 res_xhigh_po
R$5 \$3 \$4 vsubs 20600 res_xhigh_po
.ENDS pll_loop_filter
