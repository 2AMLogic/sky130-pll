* extracted by klt extract --deck sky130

* cell pll_vco_ring5
* pin vsubs
.SUBCKT pll_vco_ring5 vsubs
* device instance $1 r0 *1 0.545,1 nfet
M$1 \$15 \$14 \$13 vsubs nfet L=0.15U W=2U AS=0.94P AD=0.94P PS=4.94U PD=4.94U
* device instance $2 r0 *1 2.035,1 nfet
M$2 \$18 \$17 \$16 vsubs nfet L=0.15U W=2U AS=0.94P AD=0.94P PS=4.94U PD=4.94U
* device instance $3 r0 *1 3.525,1 nfet
M$3 \$21 \$20 \$19 vsubs nfet L=0.15U W=2U AS=0.94P AD=0.94P PS=4.94U PD=4.94U
* device instance $4 r0 *1 5.015,1 nfet
M$4 \$24 \$23 \$22 vsubs nfet L=0.15U W=2U AS=0.94P AD=0.94P PS=4.94U PD=4.94U
* device instance $5 r0 *1 6.505,1 nfet
M$5 \$27 \$26 \$25 vsubs nfet L=0.15U W=2U AS=0.94P AD=0.94P PS=4.94U PD=4.94U
* device instance $6 r0 *1 7.995,1 nfet
M$6 \$30 \$29 \$28 vsubs nfet L=0.15U W=2U AS=0.94P AD=0.94P PS=4.94U PD=4.94U
* device instance $7 r0 *1 13.21,1 nfet
M$7 \$32 \$1 \$31 vsubs nfet L=0.5U W=2U AS=0.84P AD=0.84P PS=4.84U PD=4.84U
* device instance $8 r0 *1 14.95,1 nfet
M$8 \$34 \$2 \$33 vsubs nfet L=0.5U W=2U AS=0.84P AD=0.84P PS=4.84U PD=4.84U
* device instance $9 r0 *1 16.69,1 nfet
M$9 \$36 \$3 \$35 vsubs nfet L=0.5U W=2U AS=0.84P AD=0.84P PS=4.84U PD=4.84U
* device instance $10 r0 *1 18.43,1 nfet
M$10 \$38 \$4 \$37 vsubs nfet L=0.5U W=2U AS=0.84P AD=0.84P PS=4.84U PD=4.84U
* device instance $11 r0 *1 20.17,1 nfet
M$11 \$40 \$5 \$39 vsubs nfet L=0.5U W=2U AS=0.84P AD=0.84P PS=4.84U PD=4.84U
* device instance $12 r0 *1 21.91,1 nfet
M$12 \$42 \$6 \$41 vsubs nfet L=0.5U W=2U AS=0.84P AD=0.84P PS=4.84U PD=4.84U
* device instance $13 r0 *1 27.125,4 nfet
M$13 \$45 \$44 \$43 vsubs nfet L=0.15U W=8U AS=3.76P AD=3.76P PS=16.94U
+ PD=16.94U
* device instance $14 r0 *1 32.215,2 pfet
M$14 \$48 \$47 \$46 \$79 pfet L=0.15U W=4U AS=1.88P AD=1.88P PS=8.94U PD=8.94U
* device instance $15 r0 *1 33.705,2 pfet
M$15 \$51 \$50 \$49 \$79 pfet L=0.15U W=4U AS=1.88P AD=1.88P PS=8.94U PD=8.94U
* device instance $16 r0 *1 35.195,2 pfet
M$16 \$54 \$53 \$52 \$79 pfet L=0.15U W=4U AS=1.88P AD=1.88P PS=8.94U PD=8.94U
* device instance $17 r0 *1 36.685,2 pfet
M$17 \$57 \$56 \$55 \$79 pfet L=0.15U W=4U AS=1.88P AD=1.88P PS=8.94U PD=8.94U
* device instance $18 r0 *1 38.175,2 pfet
M$18 \$60 \$59 \$58 \$79 pfet L=0.15U W=4U AS=1.88P AD=1.88P PS=8.94U PD=8.94U
* device instance $19 r0 *1 39.665,2 pfet
M$19 \$63 \$62 \$61 \$79 pfet L=0.15U W=4U AS=1.88P AD=1.88P PS=8.94U PD=8.94U
* device instance $20 r0 *1 45.18,2 pfet
M$20 \$65 \$7 \$64 \$80 pfet L=0.5U W=4U AS=1.68P AD=1.68P PS=8.84U PD=8.84U
* device instance $21 r0 *1 46.92,2 pfet
M$21 \$67 \$8 \$66 \$80 pfet L=0.5U W=4U AS=1.68P AD=1.68P PS=8.84U PD=8.84U
* device instance $22 r0 *1 48.66,2 pfet
M$22 \$69 \$9 \$68 \$80 pfet L=0.5U W=4U AS=1.68P AD=1.68P PS=8.84U PD=8.84U
* device instance $23 r0 *1 50.4,2 pfet
M$23 \$71 \$10 \$70 \$80 pfet L=0.5U W=4U AS=1.68P AD=1.68P PS=8.84U PD=8.84U
* device instance $24 r0 *1 52.14,2 pfet
M$24 \$73 \$11 \$72 \$80 pfet L=0.5U W=4U AS=1.68P AD=1.68P PS=8.84U PD=8.84U
* device instance $25 r0 *1 53.88,2 pfet
M$25 \$75 \$12 \$74 \$80 pfet L=0.5U W=4U AS=1.68P AD=1.68P PS=8.84U PD=8.84U
* device instance $26 r0 *1 59.395,8 pfet
M$26 \$78 \$77 \$76 \$81 pfet L=0.15U W=16U AS=7.52P AD=7.52P PS=32.94U
+ PD=32.94U
.ENDS pll_vco_ring5
