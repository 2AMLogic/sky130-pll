* generated by gen_watchdog.py; DUT subcircuits only (wd, wd_ctl = non-oscillating control)
.subckt wd EN RSTB RAW TICK VDD GND
XG EN RAW GND GND VDD VDD n0 sky130_fd_sc_hd__nand2_1
XD1 n0 GND GND VDD VDD d1 sky130_fd_sc_hd__dlygate4sd3_1
XD2 d1 GND GND VDD VDD d2 sky130_fd_sc_hd__dlygate4sd3_1
XD3 d2 GND GND VDD VDD d3 sky130_fd_sc_hd__dlygate4sd3_1
XD4 d3 GND GND VDD VDD d4 sky130_fd_sc_hd__dlygate4sd3_1
XD5 d4 GND GND VDD VDD RAW sky130_fd_sc_hd__dlygate4sd3_1
XF1 RAW qn1 RSTB GND GND VDD VDD q1 qn1 sky130_fd_sc_hd__dfrbp_1
XF2 q1 qn2 RSTB GND GND VDD VDD q2 qn2 sky130_fd_sc_hd__dfrbp_1
XF3 q2 qn3 RSTB GND GND VDD VDD q3 qn3 sky130_fd_sc_hd__dfrbp_1
XF4 q3 qn4 RSTB GND GND VDD VDD q4 qn4 sky130_fd_sc_hd__dfrbp_1
XF5 q4 qn5 RSTB GND GND VDD VDD q5 qn5 sky130_fd_sc_hd__dfrbp_1
XF6 q5 qn6 RSTB GND GND VDD VDD TICK qn6 sky130_fd_sc_hd__dfrbp_1
.ends
.subckt wd_ctl EN RSTB RAW TICK VDD GND
XG EN RAW GND GND VDD VDD n0 sky130_fd_sc_hd__and2_1
XD1 n0 GND GND VDD VDD d1 sky130_fd_sc_hd__dlygate4sd3_1
XD2 d1 GND GND VDD VDD d2 sky130_fd_sc_hd__dlygate4sd3_1
XD3 d2 GND GND VDD VDD d3 sky130_fd_sc_hd__dlygate4sd3_1
XD4 d3 GND GND VDD VDD d4 sky130_fd_sc_hd__dlygate4sd3_1
XD5 d4 GND GND VDD VDD RAW sky130_fd_sc_hd__dlygate4sd3_1
XF1 RAW qn1 RSTB GND GND VDD VDD q1 qn1 sky130_fd_sc_hd__dfrbp_1
XF2 q1 qn2 RSTB GND GND VDD VDD q2 qn2 sky130_fd_sc_hd__dfrbp_1
XF3 q2 qn3 RSTB GND GND VDD VDD q3 qn3 sky130_fd_sc_hd__dfrbp_1
XF4 q3 qn4 RSTB GND GND VDD VDD q4 qn4 sky130_fd_sc_hd__dfrbp_1
XF5 q4 qn5 RSTB GND GND VDD VDD q5 qn5 sky130_fd_sc_hd__dfrbp_1
XF6 q5 qn6 RSTB GND GND VDD VDD TICK qn6 sky130_fd_sc_hd__dfrbp_1
.ends
