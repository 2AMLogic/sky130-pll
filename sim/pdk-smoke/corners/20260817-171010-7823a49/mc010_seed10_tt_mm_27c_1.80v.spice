** sch_path: /Users/rwalters/GitHub/sky130-pll/.loom/worktrees/issue-20/sim/pdk-smoke/testbench/tb_pdk_smoke.sch
**.subckt tb_pdk_smoke
V1 GND net1 1.8
XR1 net1 net2 sky130_fd_pr__res_generic_po W=1 L=1 m=1
XR2 net2 GND sky130_fd_pr__res_generic_po W=1 L=1 m=1
**** begin user architecture code

** sky130 PDK model include (tt corner) -- patched per-point by sim/harness
.lib /Users/rwalters/.volare/sky130A/libs.tech/combined/sky130.lib.spice tt_mm
.op

**** end user architecture code
**.ends
.GLOBAL GND
.param MC_MM_SWITCH=1
.param MC_PR_SWITCH=1
.options seed=10
.temp 27
.end
