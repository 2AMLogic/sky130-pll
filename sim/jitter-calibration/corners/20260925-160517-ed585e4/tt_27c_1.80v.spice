** sch_path: /home/ubuntu/GitHub/sky130-pll/.loom/worktrees/issue-197/sim/jitter-calibration/testbench/tb_jitter_calibration.sch
**.subckt tb_jitter_calibration
R1 CLK GND 1k m=1
**** begin user architecture code

** GENERATED -- variant K20b: 300 cycles, nominal period
** 3.9952 ns, injected period jitter 2.000000% RMS
** (seeded RNG, seed 185020), TR = TF = 200 ps.
VCLK CLK GND pwl(
+ 0.000000n 0 1.900000n 0 2.100000n 1.8 3.967179n 1.8
+ 4.167179n 0 6.034359n 0 6.234359n 1.8 8.075350n 1.8
+ 8.275350n 0 10.116341n 0 10.316341n 1.8 12.116385n 1.8
+ 12.316385n 0 14.116429n 0 14.316429n 1.8 16.077520n 1.8
+ 16.277520n 0 18.038611n 0 18.238611n 1.8 20.009344n 1.8
+ 20.209344n 0 21.980076n 0 22.180076n 1.8 23.962783n 1.8
+ 24.162783n 0 25.945490n 0 26.145490n 1.8 27.916478n 1.8
+ 28.116478n 0 29.887466n 0 30.087466n 1.8 31.898241n 1.8
+ 32.098241n 0 33.909015n 0 34.109015n 1.8 35.947521n 1.8
+ 36.147521n 0 37.986026n 0 38.186026n 1.8 40.013895n 1.8
+ 40.213895n 0 42.041764n 0 42.241764n 1.8 43.972668n 1.8
+ 44.172668n 0 45.903572n 0 46.103572n 1.8 47.930518n 1.8
+ 48.130518n 0 49.957464n 0 50.157464n 1.8 52.011597n 1.8
+ 52.211597n 0 54.065731n 0 54.265731n 1.8 56.008163n 1.8
+ 56.208163n 0 57.950594n 0 58.150594n 1.8 59.989055n 1.8
+ 60.189055n 0 62.027516n 0 62.227516n 1.8 63.936578n 1.8
+ 64.136578n 0 65.845639n 0 66.045639n 1.8 67.837960n 1.8
+ 68.037960n 0 69.830281n 0 70.030281n 1.8 71.850432n 1.8
+ 72.050432n 0 73.870583n 0 74.070583n 1.8 75.818750n 1.8
+ 76.018750n 0 77.766917n 0 77.966917n 1.8 79.815510n 1.8
+ 80.015510n 0 81.864104n 0 82.064104n 1.8 83.853750n 1.8
+ 84.053750n 0 85.843396n 0 86.043396n 1.8 87.850864n 1.8
+ 88.050864n 0 89.858331n 0 90.058331n 1.8 91.823790n 1.8
+ 92.023790n 0 93.789249n 0 93.989249n 1.8 95.808931n 1.8
+ 96.008931n 0 97.828613n 0 98.028613n 1.8 99.876440n 1.8
+ 100.076440n 0 101.924267n 0 102.124267n 1.8 103.900169n 1.8
+ 104.100169n 0 105.876071n 0 106.076071n 1.8 107.821420n 1.8
+ 108.021420n 0 109.766768n 0 109.966768n 1.8 111.675914n 1.8
+ 111.875914n 0 113.585059n 0 113.785059n 1.8 115.616963n 1.8
+ 115.816963n 0 117.648866n 0 117.848866n 1.8 119.633226n 1.8
+ 119.833226n 0 121.617585n 0 121.817585n 1.8 123.649016n 1.8
+ 123.849016n 0 125.680446n 0 125.880446n 1.8 127.681013n 1.8
+ 127.881013n 0 129.681579n 0 129.881579n 1.8 131.646335n 1.8
+ 131.846335n 0 133.611091n 0 133.811091n 1.8 135.643270n 1.8
+ 135.843270n 0 137.675450n 0 137.875450n 1.8 139.730609n 1.8
+ 139.930609n 0 141.785768n 0 141.985768n 1.8 143.818517n 1.8
+ 144.018517n 0 145.851266n 0 146.051266n 1.8 147.855679n 1.8
+ 148.055679n 0 149.860093n 0 150.060093n 1.8 151.814093n 1.8
+ 152.014093n 0 153.768093n 0 153.968093n 1.8 155.807760n 1.8
+ 156.007760n 0 157.847427n 0 158.047427n 1.8 159.837894n 1.8
+ 160.037894n 0 161.828361n 0 162.028361n 1.8 163.754145n 1.8
+ 163.954145n 0 165.679929n 0 165.879929n 1.8 167.671647n 1.8
+ 167.871647n 0 169.663364n 0 169.863364n 1.8 171.605572n 1.8
+ 171.805572n 0 173.547779n 0 173.747779n 1.8 175.599182n 1.8
+ 175.799182n 0 177.650585n 0 177.850585n 1.8 179.676304n 1.8
+ 179.876304n 0 181.702023n 0 181.902023n 1.8 183.643350n 1.8
+ 183.843350n 0 185.584676n 0 185.784676n 1.8 187.624633n 1.8
+ 187.824633n 0 189.664589n 0 189.864589n 1.8 191.686284n 1.8
+ 191.886284n 0 193.707979n 0 193.907979n 1.8 195.704461n 1.8
+ 195.904461n 0 197.700943n 0 197.900943n 1.8 199.664993n 1.8
+ 199.864993n 0 201.629042n 0 201.829042n 1.8 203.555991n 1.8
+ 203.755991n 0 205.482940n 0 205.682940n 1.8 207.517271n 1.8
+ 207.717271n 0 209.551601n 0 209.751601n 1.8 211.542370n 1.8
+ 211.742370n 0 213.533139n 0 213.733139n 1.8 215.542598n 1.8
+ 215.742598n 0 217.552058n 0 217.752058n 1.8 219.512870n 1.8
+ 219.712870n 0 221.473682n 0 221.673682n 1.8 223.479798n 1.8
+ 223.679798n 0 225.485914n 0 225.685914n 1.8 227.501096n 1.8
+ 227.701096n 0 229.516278n 0 229.716278n 1.8 231.531514n 1.8
+ 231.731514n 0 233.546750n 0 233.746750n 1.8 235.579003n 1.8
+ 235.779003n 0 237.611255n 0 237.811255n 1.8 239.685264n 1.8
+ 239.885264n 0 241.759272n 0 241.959272n 1.8 243.693144n 1.8
+ 243.893144n 0 245.627017n 0 245.827017n 1.8 247.618948n 1.8
+ 247.818948n 0 249.610880n 0 249.810880n 1.8 251.634203n 1.8
+ 251.834203n 0 253.657526n 0 253.857526n 1.8 255.640002n 1.8
+ 255.840002n 0 257.622478n 0 257.822478n 1.8 259.618335n 1.8
+ 259.818335n 0 261.614191n 0 261.814191n 1.8 263.598725n 1.8
+ 263.798725n 0 265.583258n 0 265.783258n 1.8 267.656161n 1.8
+ 267.856161n 0 269.729065n 0 269.929065n 1.8 271.732474n 1.8
+ 271.932474n 0 273.735883n 0 273.935883n 1.8 275.750723n 1.8
+ 275.950723n 0 277.765564n 0 277.965564n 1.8 279.790094n 1.8
+ 279.990094n 0 281.814625n 0 282.014625n 1.8 283.773830n 1.8
+ 283.973830n 0 285.733035n 0 285.933035n 1.8 287.765825n 1.8
+ 287.965825n 0 289.798614n 0 289.998614n 1.8 291.801144n 1.8
+ 292.001144n 0 293.803673n 0 294.003673n 1.8 295.735707n 1.8
+ 295.935707n 0 297.667740n 0 297.867740n 1.8 299.710639n 1.8
+ 299.910639n 0 301.753538n 0 301.953538n 1.8 303.729818n 1.8
+ 303.929818n 0 305.706098n 0 305.906098n 1.8 307.673606n 1.8
+ 307.873606n 0 309.641115n 0 309.841115n 1.8 311.669988n 1.8
+ 311.869988n 0 313.698860n 0 313.898860n 1.8 315.652579n 1.8
+ 315.852579n 0 317.606297n 0 317.806297n 1.8 319.688378n 1.8
+ 319.888378n 0 321.770459n 0 321.970459n 1.8 323.677206n 1.8
+ 323.877206n 0 325.583953n 0 325.783953n 1.8 327.570580n 1.8
+ 327.770580n 0 329.557207n 0 329.757207n 1.8 331.640001n 1.8
+ 331.840001n 0 333.722795n 0 333.922795n 1.8 335.644479n 1.8
+ 335.844479n 0 337.566162n 0 337.766162n 1.8 339.511818n 1.8
+ 339.711818n 0 341.457475n 0 341.657475n 1.8 343.490774n 1.8
+ 343.690774n 0 345.524074n 0 345.724074n 1.8 347.508430n 1.8
+ 347.708430n 0 349.492787n 0 349.692787n 1.8 351.486203n 1.8
+ 351.686203n 0 353.479619n 0 353.679619n 1.8 355.509367n 1.8
+ 355.709367n 0 357.539115n 0 357.739115n 1.8 359.560750n 1.8
+ 359.760750n 0 361.582385n 0 361.782385n 1.8 363.602648n 1.8
+ 363.802648n 0 365.622911n 0 365.822911n 1.8 367.618198n 1.8
+ 367.818198n 0 369.613485n 0 369.813485n 1.8 371.591206n 1.8
+ 371.791206n 0 373.568927n 0 373.768927n 1.8 375.501591n 1.8
+ 375.701591n 0 377.434255n 0 377.634255n 1.8 379.429331n 1.8
+ 379.629331n 0 381.424407n 0 381.624407n 1.8 383.422880n 1.8
+ 383.622880n 0 385.421354n 0 385.621354n 1.8 387.408325n 1.8
+ 387.608325n 0 389.395295n 0 389.595295n 1.8 391.342015n 1.8
+ 391.542015n 0 393.288735n 0 393.488735n 1.8 395.287265n 1.8
+ 395.487265n 0 397.285795n 0 397.485795n 1.8 399.386832n 1.8
+ 399.586832n 0 401.487868n 0 401.687868n 1.8 403.465565n 1.8
+ 403.665565n 0 405.443261n 0 405.643261n 1.8 407.392500n 1.8
+ 407.592500n 0 409.341739n 0 409.541739n 1.8 411.364125n 1.8
+ 411.564125n 0 413.386512n 0 413.586512n 1.8 415.308840n 1.8
+ 415.508840n 0 417.231169n 0 417.431169n 1.8 419.184294n 1.8
+ 419.384294n 0 421.137418n 0 421.337418n 1.8 423.089606n 1.8
+ 423.289606n 0 425.041794n 0 425.241794n 1.8 427.046502n 1.8
+ 427.246502n 0 429.051210n 0 429.251210n 1.8 430.973202n 1.8
+ 431.173202n 0 432.895194n 0 433.095194n 1.8 434.911734n 1.8
+ 435.111734n 0 436.928274n 0 437.128274n 1.8 438.863438n 1.8
+ 439.063438n 0 440.798601n 0 440.998601n 1.8 442.806656n 1.8
+ 443.006656n 0 444.814711n 0 445.014711n 1.8 446.829450n 1.8
+ 447.029450n 0 448.844190n 0 449.044190n 1.8 450.870650n 1.8
+ 451.070650n 0 452.897111n 0 453.097111n 1.8 454.865023n 1.8
+ 455.065023n 0 456.832935n 0 457.032935n 1.8 458.823140n 1.8
+ 459.023140n 0 460.813345n 0 461.013345n 1.8 462.804520n 1.8
+ 463.004520n 0 464.795696n 0 464.995696n 1.8 466.834116n 1.8
+ 467.034116n 0 468.872535n 0 469.072535n 1.8 470.902441n 1.8
+ 471.102441n 0 472.932348n 0 473.132348n 1.8 474.939636n 1.8
+ 475.139636n 0 476.946925n 0 477.146925n 1.8 478.905556n 1.8
+ 479.105556n 0 480.864186n 0 481.064186n 1.8 482.911666n 1.8
+ 483.111666n 0 484.959145n 0 485.159145n 1.8 486.971573n 1.8
+ 487.171573n 0 488.984001n 0 489.184001n 1.8 490.972510n 1.8
+ 491.172510n 0 492.961019n 0 493.161019n 1.8 494.987930n 1.8
+ 495.187930n 0 497.014840n 0 497.214840n 1.8 499.021634n 1.8
+ 499.221634n 0 501.028427n 0 501.228427n 1.8 503.079649n 1.8
+ 503.279649n 0 505.130871n 0 505.330871n 1.8 507.123740n 1.8
+ 507.323740n 0 509.116610n 0 509.316610n 1.8 511.180388n 1.8
+ 511.380388n 0 513.244167n 0 513.444167n 1.8 515.308111n 1.8
+ 515.508111n 0 517.372055n 0 517.572055n 1.8 519.337804n 1.8
+ 519.537804n 0 521.303554n 0 521.503554n 1.8 523.322637n 1.8
+ 523.522637n 0 525.341719n 0 525.541719n 1.8 527.361105n 1.8
+ 527.561105n 0 529.380491n 0 529.580491n 1.8 531.382526n 1.8
+ 531.582526n 0 533.384561n 0 533.584561n 1.8 535.397278n 1.8
+ 535.597278n 0 537.409995n 0 537.609995n 1.8 539.459536n 1.8
+ 539.659536n 0 541.509076n 0 541.709076n 1.8 543.558871n 1.8
+ 543.758871n 0 545.608666n 0 545.808666n 1.8 547.666871n 1.8
+ 547.866871n 0 549.725077n 0 549.925077n 1.8 551.746237n 1.8
+ 551.946237n 0 553.767396n 0 553.967396n 1.8 555.734192n 1.8
+ 555.934192n 0 557.700987n 0 557.900987n 1.8 559.715580n 1.8
+ 559.915580n 0 561.730174n 0 561.930174n 1.8 563.704235n 1.8
+ 563.904235n 0 565.678295n 0 565.878295n 1.8 567.701613n 1.8
+ 567.901613n 0 569.724930n 0 569.924930n 1.8 571.752631n 1.8
+ 571.952631n 0 573.780332n 0 573.980332n 1.8 575.843109n 1.8
+ 576.043109n 0 577.905886n 0 578.105886n 1.8 579.882812n 1.8
+ 580.082812n 0 581.859737n 0 582.059737n 1.8 583.867887n 1.8
+ 584.067887n 0 585.876037n 0 586.076037n 1.8 587.840393n 1.8
+ 588.040393n 0 589.804749n 0 590.004749n 1.8 591.875034n 1.8
+ 592.075034n 0 593.945319n 0 594.145319n 1.8 595.937330n 1.8
+ 596.137330n 0 597.929340n 0 598.129340n 1.8 599.924560n 1.8
+ 600.124560n 0 601.919780n 0 602.119780n 1.8 603.923792n 1.8
+ 604.123792n 0 605.927805n 0 606.127805n 1.8 607.924330n 1.8
+ 608.124330n 0 609.920855n 0 610.120855n 1.8 611.868522n 1.8
+ 612.068522n 0 613.816188n 0 614.016188n 1.8 615.856606n 1.8
+ 616.056606n 0 617.897025n 0 618.097025n 1.8 619.870325n 1.8
+ 620.070325n 0 621.843626n 0 622.043626n 1.8 623.795024n 1.8
+ 623.995024n 0 625.746421n 0 625.946421n 1.8 627.767201n 1.8
+ 627.967201n 0 629.787981n 0 629.987981n 1.8 631.831875n 1.8
+ 632.031875n 0 633.875769n 0 634.075769n 1.8 635.911323n 1.8
+ 636.111323n 0 637.946876n 0 638.146876n 1.8 639.965308n 1.8
+ 640.165308n 0 641.983740n 0 642.183740n 1.8 643.951616n 1.8
+ 644.151616n 0 645.919492n 0 646.119492n 1.8 647.844039n 1.8
+ 648.044039n 0 649.768585n 0 649.968585n 1.8 651.748829n 1.8
+ 651.948829n 0 653.729073n 0 653.929073n 1.8 655.695500n 1.8
+ 655.895500n 0 657.661927n 0 657.861927n 1.8 659.697168n 1.8
+ 659.897168n 0 661.732409n 0 661.932409n 1.8 663.751740n 1.8
+ 663.951740n 0 665.771071n 0 665.971071n 1.8 667.815826n 1.8
+ 668.015826n 0 669.860580n 0 670.060580n 1.8 671.805403n 1.8
+ 672.005403n 0 673.750227n 0 673.950227n 1.8 675.771890n 1.8
+ 675.971890n 0 677.793554n 0 677.993554n 1.8 679.821996n 1.8
+ 680.021996n 0 681.850439n 0 682.050439n 1.8 683.790397n 1.8
+ 683.990397n 0 685.730355n 0 685.930355n 1.8 687.743389n 1.8
+ 687.943389n 0 689.756423n 0 689.956423n 1.8 691.785979n 1.8
+ 691.985979n 0 693.815534n 0 694.015534n 1.8 695.842139n 1.8
+ 696.042139n 0 697.868744n 0 698.068744n 1.8 699.846721n 1.8
+ 700.046721n 0 701.824697n 0 702.024697n 1.8 703.814445n 1.8
+ 704.014445n 0 705.804192n 0 706.004192n 1.8 707.806887n 1.8
+ 708.006887n 0 709.809581n 0 710.009581n 1.8 711.779664n 1.8
+ 711.979664n 0 713.749746n 0 713.949746n 1.8 715.736391n 1.8
+ 715.936391n 0 717.723037n 0 717.923037n 1.8 719.711898n 1.8
+ 719.911898n 0 721.700759n 0 721.900759n 1.8 723.690916n 1.8
+ 723.890916n 0 725.681073n 0 725.881073n 1.8 727.676579n 1.8
+ 727.876579n 0 729.672084n 0 729.872084n 1.8 731.706655n 1.8
+ 731.906655n 0 733.741226n 0 733.941226n 1.8 735.696138n 1.8
+ 735.896138n 0 737.651051n 0 737.851051n 1.8 739.634508n 1.8
+ 739.834508n 0 741.617964n 0 741.817964n 1.8 743.575763n 1.8
+ 743.775763n 0 745.533561n 0 745.733561n 1.8 747.457840n 1.8
+ 747.657840n 0 749.382120n 0 749.582120n 1.8 751.368238n 1.8
+ 751.568238n 0 753.354356n 0 753.554356n 1.8 755.318565n 1.8
+ 755.518565n 0 757.282774n 0 757.482774n 1.8 759.284137n 1.8
+ 759.484137n 0 761.285499n 0 761.485499n 1.8 763.281321n 1.8
+ 763.481321n 0 765.277144n 0 765.477144n 1.8 767.211170n 1.8
+ 767.411170n 0 769.145197n 0 769.345197n 1.8 771.108488n 1.8
+ 771.308488n 0 773.071779n 0 773.271779n 1.8 775.065732n 1.8
+ 775.265732n 0 777.059684n 0 777.259684n 1.8 779.085099n 1.8
+ 779.285099n 0 781.110514n 0 781.310514n 1.8 783.112581n 1.8
+ 783.312581n 0 785.114649n 0 785.314649n 1.8 787.100495n 1.8
+ 787.300495n 0 789.086341n 0 789.286341n 1.8 791.049158n 1.8
+ 791.249158n 0 793.011975n 0 793.211975n 1.8 795.037667n 1.8
+ 795.237667n 0 797.063358n 0 797.263358n 1.8 799.074543n 1.8
+ 799.274543n 0 801.085729n 0 801.285729n 1.8 803.099911n 1.8
+ 803.299911n 0 805.114092n 0 805.314092n 1.8 807.140737n 1.8
+ 807.340737n 0 809.167381n 0 809.367381n 1.8 811.164799n 1.8
+ 811.364799n 0 813.162217n 0 813.362217n 1.8 815.245926n 1.8
+ 815.445926n 0 817.329635n 0 817.529635n 1.8 819.319952n 1.8
+ 819.519952n 0 821.310269n 0 821.510269n 1.8 823.346184n 1.8
+ 823.546184n 0 825.382098n 0 825.582098n 1.8 827.399313n 1.8
+ 827.599313n 0 829.416528n 0 829.616528n 1.8 831.388379n 1.8
+ 831.588379n 0 833.360229n 0 833.560229n 1.8 835.403741n 1.8
+ 835.603741n 0 837.447252n 0 837.647252n 1.8 839.471391n 1.8
+ 839.671391n 0 841.495530n 0 841.695530n 1.8 843.489554n 1.8
+ 843.689554n 0 845.483578n 0 845.683578n 1.8 847.401900n 1.8
+ 847.601900n 0 849.320222n 0 849.520222n 1.8 851.338136n 1.8
+ 851.538136n 0 853.356049n 0 853.556049n 1.8 855.363601n 1.8
+ 855.563601n 0 857.371153n 0 857.571153n 1.8 859.319895n 1.8
+ 859.519895n 0 861.268637n 0 861.468637n 1.8 863.321158n 1.8
+ 863.521158n 0 865.373679n 0 865.573679n 1.8 867.330645n 1.8
+ 867.530645n 0 869.287611n 0 869.487611n 1.8 871.342867n 1.8
+ 871.542867n 0 873.398124n 0 873.598124n 1.8 875.367393n 1.8
+ 875.567393n 0 877.336662n 0 877.536662n 1.8 879.341757n 1.8
+ 879.541757n 0 881.346851n 0 881.546851n 1.8 883.347166n 1.8
+ 883.547166n 0 885.347480n 0 885.547480n 1.8 887.361463n 1.8
+ 887.561463n 0 889.375446n 0 889.575446n 1.8 891.282636n 1.8
+ 891.482636n 0 893.189826n 0 893.389826n 1.8 895.137453n 1.8
+ 895.337453n 0 897.085079n 0 897.285079n 1.8 899.126554n 1.8
+ 899.326554n 0 901.168028n 0 901.368028n 1.8 903.145554n 1.8
+ 903.345554n 0 905.123080n 0 905.323080n 1.8 907.202864n 1.8
+ 907.402864n 0 909.282648n 0 909.482648n 1.8 911.292349n 1.8
+ 911.492349n 0 913.302050n 0 913.502050n 1.8 915.265396n 1.8
+ 915.465396n 0 917.228741n 0 917.428741n 1.8 919.273388n 1.8
+ 919.473388n 0 921.318035n 0 921.518035n 1.8 923.359727n 1.8
+ 923.559727n 0 925.401418n 0 925.601418n 1.8 927.423512n 1.8
+ 927.623512n 0 929.445607n 0 929.645607n 1.8 931.470452n 1.8
+ 931.670452n 0 933.495297n 0 933.695297n 1.8 935.580371n 1.8
+ 935.780371n 0 937.665445n 0 937.865445n 1.8 939.641542n 1.8
+ 939.841542n 0 941.617639n 0 941.817639n 1.8 943.651762n 1.8
+ 943.851762n 0 945.685884n 0 945.885884n 1.8 947.674911n 1.8
+ 947.874911n 0 949.663939n 0 949.863939n 1.8 951.691821n 1.8
+ 951.891821n 0 953.719703n 0 953.919703n 1.8 955.764958n 1.8
+ 955.964958n 0 957.810214n 0 958.010214n 1.8 959.784788n 1.8
+ 959.984788n 0 961.759363n 0 961.959363n 1.8 963.729855n 1.8
+ 963.929855n 0 965.700347n 0 965.900347n 1.8 967.667274n 1.8
+ 967.867274n 0 969.634200n 0 969.834200n 1.8 971.627339n 1.8
+ 971.827339n 0 973.620478n 0 973.820478n 1.8 975.585314n 1.8
+ 975.785314n 0 977.550151n 0 977.750151n 1.8 979.405783n 1.8
+ 979.605783n 0 981.261415n 0 981.461415n 1.8 983.273862n 1.8
+ 983.473862n 0 985.286310n 0 985.486310n 1.8 987.278509n 1.8
+ 987.478509n 0 989.270709n 0 989.470709n 1.8 991.245217n 1.8
+ 991.445217n 0 993.219724n 0 993.419724n 1.8 995.146052n 1.8
+ 995.346052n 0 997.072380n 0 997.272380n 1.8 999.024389n 1.8
+ 999.224389n 0 1000.976397n 0 1001.176397n 1.8 1002.918115n 1.8
+ 1003.118115n 0 1004.859833n 0 1005.059833n 1.8 1006.878882n 1.8
+ 1007.078882n 0 1008.897932n 0 1009.097932n 1.8 1010.909989n 1.8
+ 1011.109989n 0 1012.922046n 0 1013.122046n 1.8 1014.929520n 1.8
+ 1015.129520n 0 1016.936994n 0 1017.136994n 1.8 1018.935043n 1.8
+ 1019.135043n 0 1020.933093n 0 1021.133093n 1.8 1022.914474n 1.8
+ 1023.114474n 0 1024.895856n 0 1025.095856n 1.8 1026.888392n 1.8
+ 1027.088392n 0 1028.880929n 0 1029.080929n 1.8 1030.772946n 1.8
+ 1030.972946n 0 1032.664963n 0 1032.864963n 1.8 1034.692186n 1.8
+ 1034.892186n 0 1036.719409n 0 1036.919409n 1.8 1038.655363n 1.8
+ 1038.855363n 0 1040.591317n 0 1040.791317n 1.8 1042.583636n 1.8
+ 1042.783636n 0 1044.575956n 0 1044.775956n 1.8 1046.548343n 1.8
+ 1046.748343n 0 1048.520731n 0 1048.720731n 1.8 1050.477418n 1.8
+ 1050.677418n 0 1052.434106n 0 1052.634106n 1.8 1054.467254n 1.8
+ 1054.667254n 0 1056.500402n 0 1056.700402n 1.8 1058.567532n 1.8
+ 1058.767532n 0 1060.634663n 0 1060.834663n 1.8 1062.633112n 1.8
+ 1062.833112n 0 1064.631561n 0 1064.831561n 1.8 1066.622277n 1.8
+ 1066.822277n 0 1068.612994n 0 1068.812994n 1.8 1070.524441n 1.8
+ 1070.724441n 0 1072.435888n 0 1072.635888n 1.8 1074.465757n 1.8
+ 1074.665757n 0 1076.495626n 0 1076.695626n 1.8 1078.433356n 1.8
+ 1078.633356n 0 1080.371087n 0 1080.571087n 1.8 1082.389947n 1.8
+ 1082.589947n 0 1084.408807n 0 1084.608807n 1.8 1086.479814n 1.8
+ 1086.679814n 0 1088.550822n 0 1088.750822n 1.8 1090.595628n 1.8
+ 1090.795628n 0 1092.640433n 0 1092.840433n 1.8 1094.683716n 1.8
+ 1094.883716n 0 1096.726998n 0 1096.926998n 1.8 1098.653443n 1.8
+ 1098.853443n 0 1100.579887n 0 1100.779887n 1.8 1102.614594n 1.8
+ 1102.814594n 0 1104.649301n 0 1104.849301n 1.8 1106.656767n 1.8
+ 1106.856767n 0 1108.664232n 0 1108.864232n 1.8 1110.630751n 1.8
+ 1110.830751n 0 1112.597270n 0 1112.797270n 1.8 1114.608087n 1.8
+ 1114.808087n 0 1116.618904n 0 1116.818904n 1.8 1118.603938n 1.8
+ 1118.803938n 0 1120.588972n 0 1120.788972n 1.8 1122.598051n 1.8
+ 1122.798051n 0 1124.607131n 0 1124.807131n 1.8 1126.566359n 1.8
+ 1126.766359n 0 1128.525587n 0 1128.725587n 1.8 1130.523156n 1.8
+ 1130.723156n 0 1132.520725n 0 1132.720725n 1.8 1134.538023n 1.8
+ 1134.738023n 0 1136.555321n 0 1136.755321n 1.8 1138.601305n 1.8
+ 1138.801305n 0 1140.647288n 0 1140.847288n 1.8 1142.651723n 1.8
+ 1142.851723n 0 1144.656158n 0 1144.856158n 1.8 1146.637316n 1.8
+ 1146.837316n 0 1148.618473n 0 1148.818473n 1.8 1150.655704n 1.8
+ 1150.855704n 0 1152.692934n 0 1152.892934n 1.8 1154.652950n 1.8
+ 1154.852950n 0 1156.612966n 0 1156.812966n 1.8 1158.632313n 1.8
+ 1158.832313n 0 1160.651661n 0 1160.851661n 1.8 1162.608312n 1.8
+ 1162.808312n 0 1164.564962n 0 1164.764962n 1.8 1166.567510n 1.8
+ 1166.767510n 0 1168.570057n 0 1168.770057n 1.8 1170.585928n 1.8
+ 1170.785928n 0 1172.601799n 0 1172.801799n 1.8 1174.582856n 1.8
+ 1174.782856n 0 1176.563913n 0 1176.763913n 1.8 1178.573592n 1.8
+ 1178.773592n 0 1180.583271n 0 1180.783271n 1.8 1182.568008n 1.8
+ 1182.768008n 0 1184.552746n 0 1184.752746n 1.8 1186.544563n 1.8
+ 1186.744563n 0 1188.536379n 0 1188.736379n 1.8 1190.527935n 1.8
+ 1190.727935n 0 1192.519490n 0 1192.719490n 1.8 1194.522730n 1.8
+ 1194.722730n 0 1196.525970n 0 1196.725970n 1.8 1198.492985n 1.8
+ 1198.692985n 0 1200.460000n 0 1200.660000n 1.8 1202.457600n 1.8
+ 1202.657600n 0
+ )

** sky130 PDK model include (tt corner) -- patched per-point by sim/harness.
** No device in this testbench uses it: it is here so the harness's own
** corner substitution and this record's environment provenance are the same
** as every other campaign's. See this file's header comment.
.lib /home/ubuntu/.volare/sky130A/libs.tech/combined/sky130.lib.spice tt
** No .tran/.print card here on purpose -- sim/harness/measure.py injects the
** analysis from this manifest's own measure block.

**** end user architecture code
**.ends
.GLOBAL GND
.temp 27
.control
set filetype=ascii
save v(CLK)
tran 200p 1.25u
linearize v(CLK)
wrdata tt_27c_1.80v-point000.raw v(CLK)
destroy all
echo "sim/harness: analysis complete"
.endc
.end
