** sch_path: (machine-local path elided)
**.subckt tb_power_divider_n4
XXXDIV VDD GND CLK RESETB VDD VDD GND GND GND GND FBCLK divider_intN
V1 VDD GND 1.8
VCK100 CK100 GND pulse(0 1 0 100p 100p 4.9n 10n)
VCK250 CK250 GND pulse(0 1 0 100p 100p 1.9n 4n)
VEN100m EN100m GND pwl(0 0 107n 0 107.1n 1 227n 1 227.1n 0)
VEN250m EN250m GND pwl(0 0 227n 0 227.1n 1 287n 1 287.1n 0)
BCLK CLK GND V = v(VDD)*(v(CK100)*v(EN100m)+v(CK250)*v(EN250m)) m=1
VRST RSTU GND pwl(0 0 5n 0 5.1n 1)
BRST RESETB GND V = v(VDD)*v(RSTU) m=1
**** begin user architecture code

** std-cell subckt library for the divider's gates (resolved on the executing host)
.include $PDK_ROOT/sky130A/libs.ref/sky130_fd_sc_hd/spice/sky130_fd_sc_hd.spice

**** end user architecture code
**.ends

* expanding   symbol:  design/divider/divider_intN.sym # of pins=11
** sym_path: (machine-local path elided)
** sch_path: (machine-local path elided)
.subckt divider_intN VDD GND CLK RESETB NSEL0 NSEL1 NSEL2 NSEL3 NSEL4 NSEL5 FBCLK
*.iopin VDD
*.iopin GND
*.ipin CLK
*.ipin RESETB
*.ipin NSEL0
*.ipin NSEL1
*.ipin NSEL2
*.ipin NSEL3
*.ipin NSEL4
*.ipin NSEL5
*.opin FBCLK
XCNT0 PCLK D0 RESETB GND GND VDD VDD Q0 sky130_fd_sc_hd__dfrtp_2
XLDMUX0 NQ0 L0 ZERO GND GND VDD VDD D0 sky130_fd_sc_hd__mux2_2
XQINV0 Q0 GND GND VDD VDD NQ0 sky130_fd_sc_hd__inv_2
XCNT1 PCLK D1 RESETB GND GND VDD VDD Q1 sky130_fd_sc_hd__dfrtp_2
XLDMUX1 DDEC1 L1 ZERO GND GND VDD VDD D1 sky130_fd_sc_hd__mux2_2
XDECXOR1 Q1 NQ0 GND GND VDD VDD DDEC1 sky130_fd_sc_hd__xor2_2
XQINV1 Q1 GND GND VDD VDD NQ1 sky130_fd_sc_hd__inv_2
XCNT2 PCLK D2 RESETB GND GND VDD VDD Q2 sky130_fd_sc_hd__dfrtp_2
XLDMUX2 DDEC2 L2 ZERO GND GND VDD VDD D2 sky130_fd_sc_hd__mux2_2
XDECXOR2 Q2 BOR2 GND GND VDD VDD DDEC2 sky130_fd_sc_hd__xor2_2
XBORAND2 NQ0 NQ1 GND GND VDD VDD BOR2 sky130_fd_sc_hd__and2_2
XQINV2 Q2 GND GND VDD VDD NQ2 sky130_fd_sc_hd__inv_2
XCNT3 PCLK D3 RESETB GND GND VDD VDD Q3 sky130_fd_sc_hd__dfrtp_2
XLDMUX3 DDEC3 L3 ZERO GND GND VDD VDD D3 sky130_fd_sc_hd__mux2_2
XDECXOR3 Q3 BOR3 GND GND VDD VDD DDEC3 sky130_fd_sc_hd__xor2_2
XBORAND3 NQ0 NQ1 NQ2 GND GND VDD VDD BOR3 sky130_fd_sc_hd__and3_2
XQINV3 Q3 GND GND VDD VDD NQ3 sky130_fd_sc_hd__inv_2
XCNT4 PCLK D4 RESETB GND GND VDD VDD Q4 sky130_fd_sc_hd__dfrtp_2
XLDMUX4 DDEC4 L4 ZERO GND GND VDD VDD D4 sky130_fd_sc_hd__mux2_2
XDECXOR4 Q4 BOR4 GND GND VDD VDD DDEC4 sky130_fd_sc_hd__xor2_2
XBORAND4 NQ0 NQ1 NQ2 NQ3 GND GND VDD VDD BOR4 sky130_fd_sc_hd__and4_2
XQINV4 Q4 GND GND VDD VDD NQ4 sky130_fd_sc_hd__inv_2
XZDET BOR4 NQ4 GND GND VDD VDD ZERO sky130_fd_sc_hd__and2_2
XPA CLK DPA RESETB GND GND VDD VDD PA sky130_fd_sc_hd__dfrtp_2
XPANOR PA PB GND GND VDD VDD DPA sky130_fd_sc_hd__nor2_2
XPB CLK DPB RESETB GND GND VDD VDD PB sky130_fd_sc_hd__dfrtp_2
XPBAND PA MC GND GND VDD VDD DPB sky130_fd_sc_hd__and2_2
XPCKINV PA GND GND VDD VDD PCLK sky130_fd_sc_hd__inv_2
XMCFF PCLK DMC RESETB GND GND VDD VDD MC sky130_fd_sc_hd__dfrtp_2
XMCAND ODD ZERO GND GND VDD VDD DMC sky130_fd_sc_hd__and2_2
XFBFF PCLK ZERO GND GND VDD VDD FBCLK sky130_fd_sc_hd__dfxtp_2
XODD NSEL0 GND GND VDD VDD ODD sky130_fd_sc_hd__inv_2
XNB2 NSEL0 NSEL1 GND GND VDD VDD NB2 sky130_fd_sc_hd__nor2_2
XNB3 NSEL0 NSEL1 NSEL2 GND GND VDD VDD NB3 sky130_fd_sc_hd__nor3_2
XNB4 NSEL0 NSEL1 NSEL2 NSEL3 GND GND VDD VDD NB4 sky130_fd_sc_hd__nor4_2
XNS4INV NSEL4 GND GND VDD VDD NNSEL4 sky130_fd_sc_hd__inv_2
XNB5 NB4 NNSEL4 GND GND VDD VDD NB5 sky130_fd_sc_hd__and2_2
XLDEC0 NSEL1 NSEL0 GND GND VDD VDD L0 sky130_fd_sc_hd__xnor2_2
XLDEC1 NSEL2 NB2 GND GND VDD VDD L1 sky130_fd_sc_hd__xor2_2
XLDEC2 NSEL3 NB3 GND GND VDD VDD L2 sky130_fd_sc_hd__xor2_2
XLDEC3 NSEL4 NB4 GND GND VDD VDD L3 sky130_fd_sc_hd__xor2_2
XLDEC4 NSEL5 NB5 GND GND VDD VDD L4 sky130_fd_sc_hd__xor2_2
.ends

.GLOBAL GND

.save v(fbclk) i(v1) v(clk)
