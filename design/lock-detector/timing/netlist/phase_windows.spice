* generated by gen_phase_windows.py; DUT subcircuits only
.subckt phase_win_s50 IN ACQ REL VDD GND
XACQ1 IN GND GND VDD VDD acq1 sky130_fd_sc_hd__clkdlybuf4s50_1
XACQ2 acq1 GND GND VDD VDD acq2 sky130_fd_sc_hd__clkdlybuf4s50_1
XACQ3 acq2 GND GND VDD VDD acq3 sky130_fd_sc_hd__clkdlybuf4s50_1
XACQ4 acq3 GND GND VDD VDD acq4 sky130_fd_sc_hd__clkdlybuf4s50_1
XACQ5 acq4 GND GND VDD VDD acq5 sky130_fd_sc_hd__clkdlybuf4s50_1
XACQ6 acq5 GND GND VDD VDD acq6 sky130_fd_sc_hd__clkdlybuf4s50_1
XACQ7 acq6 GND GND VDD VDD ACQ sky130_fd_sc_hd__clkdlybuf4s50_1
XREL1 IN GND GND VDD VDD rel1 sky130_fd_sc_hd__clkdlybuf4s50_1
XREL2 rel1 GND GND VDD VDD rel2 sky130_fd_sc_hd__clkdlybuf4s50_1
XREL3 rel2 GND GND VDD VDD rel3 sky130_fd_sc_hd__clkdlybuf4s50_1
XREL4 rel3 GND GND VDD VDD rel4 sky130_fd_sc_hd__clkdlybuf4s50_1
XREL5 rel4 GND GND VDD VDD rel5 sky130_fd_sc_hd__clkdlybuf4s50_1
XREL6 rel5 GND GND VDD VDD rel6 sky130_fd_sc_hd__clkdlybuf4s50_1
XREL7 rel6 GND GND VDD VDD rel7 sky130_fd_sc_hd__clkdlybuf4s50_1
XREL8 rel7 GND GND VDD VDD rel8 sky130_fd_sc_hd__clkdlybuf4s50_1
XREL9 rel8 GND GND VDD VDD rel9 sky130_fd_sc_hd__clkdlybuf4s50_1
XREL10 rel9 GND GND VDD VDD rel10 sky130_fd_sc_hd__clkdlybuf4s50_1
XREL11 rel10 GND GND VDD VDD rel11 sky130_fd_sc_hd__clkdlybuf4s50_1
XREL12 rel11 GND GND VDD VDD rel12 sky130_fd_sc_hd__clkdlybuf4s50_1
XREL13 rel12 GND GND VDD VDD rel13 sky130_fd_sc_hd__clkdlybuf4s50_1
XREL14 rel13 GND GND VDD VDD rel14 sky130_fd_sc_hd__clkdlybuf4s50_1
XREL15 rel14 GND GND VDD VDD rel15 sky130_fd_sc_hd__clkdlybuf4s50_1
XREL16 rel15 GND GND VDD VDD rel16 sky130_fd_sc_hd__clkdlybuf4s50_1
XREL17 rel16 GND GND VDD VDD rel17 sky130_fd_sc_hd__clkdlybuf4s50_1
XREL18 rel17 GND GND VDD VDD REL sky130_fd_sc_hd__clkdlybuf4s50_1
.ends

.subckt phase_win_s25 IN ACQ REL VDD GND
XACQ1 IN GND GND VDD VDD acq1 sky130_fd_sc_hd__clkdlybuf4s25_1
XACQ2 acq1 GND GND VDD VDD acq2 sky130_fd_sc_hd__clkdlybuf4s25_1
XACQ3 acq2 GND GND VDD VDD acq3 sky130_fd_sc_hd__clkdlybuf4s25_1
XACQ4 acq3 GND GND VDD VDD acq4 sky130_fd_sc_hd__clkdlybuf4s25_1
XACQ5 acq4 GND GND VDD VDD acq5 sky130_fd_sc_hd__clkdlybuf4s25_1
XACQ6 acq5 GND GND VDD VDD acq6 sky130_fd_sc_hd__clkdlybuf4s25_1
XACQ7 acq6 GND GND VDD VDD acq7 sky130_fd_sc_hd__clkdlybuf4s25_1
XACQ8 acq7 GND GND VDD VDD acq8 sky130_fd_sc_hd__clkdlybuf4s25_1
XACQ9 acq8 GND GND VDD VDD acq9 sky130_fd_sc_hd__clkdlybuf4s25_1
XACQ10 acq9 GND GND VDD VDD acq10 sky130_fd_sc_hd__clkdlybuf4s25_1
XACQ11 acq10 GND GND VDD VDD acq11 sky130_fd_sc_hd__clkdlybuf4s25_1
XACQ12 acq11 GND GND VDD VDD acq12 sky130_fd_sc_hd__clkdlybuf4s25_1
XACQ13 acq12 GND GND VDD VDD acq13 sky130_fd_sc_hd__clkdlybuf4s25_1
XACQ14 acq13 GND GND VDD VDD ACQ sky130_fd_sc_hd__clkdlybuf4s25_1
XREL1 IN GND GND VDD VDD rel1 sky130_fd_sc_hd__clkdlybuf4s25_1
XREL2 rel1 GND GND VDD VDD rel2 sky130_fd_sc_hd__clkdlybuf4s25_1
XREL3 rel2 GND GND VDD VDD rel3 sky130_fd_sc_hd__clkdlybuf4s25_1
XREL4 rel3 GND GND VDD VDD rel4 sky130_fd_sc_hd__clkdlybuf4s25_1
XREL5 rel4 GND GND VDD VDD rel5 sky130_fd_sc_hd__clkdlybuf4s25_1
XREL6 rel5 GND GND VDD VDD rel6 sky130_fd_sc_hd__clkdlybuf4s25_1
XREL7 rel6 GND GND VDD VDD rel7 sky130_fd_sc_hd__clkdlybuf4s25_1
XREL8 rel7 GND GND VDD VDD rel8 sky130_fd_sc_hd__clkdlybuf4s25_1
XREL9 rel8 GND GND VDD VDD rel9 sky130_fd_sc_hd__clkdlybuf4s25_1
XREL10 rel9 GND GND VDD VDD rel10 sky130_fd_sc_hd__clkdlybuf4s25_1
XREL11 rel10 GND GND VDD VDD rel11 sky130_fd_sc_hd__clkdlybuf4s25_1
XREL12 rel11 GND GND VDD VDD rel12 sky130_fd_sc_hd__clkdlybuf4s25_1
XREL13 rel12 GND GND VDD VDD rel13 sky130_fd_sc_hd__clkdlybuf4s25_1
XREL14 rel13 GND GND VDD VDD rel14 sky130_fd_sc_hd__clkdlybuf4s25_1
XREL15 rel14 GND GND VDD VDD rel15 sky130_fd_sc_hd__clkdlybuf4s25_1
XREL16 rel15 GND GND VDD VDD rel16 sky130_fd_sc_hd__clkdlybuf4s25_1
XREL17 rel16 GND GND VDD VDD rel17 sky130_fd_sc_hd__clkdlybuf4s25_1
XREL18 rel17 GND GND VDD VDD rel18 sky130_fd_sc_hd__clkdlybuf4s25_1
XREL19 rel18 GND GND VDD VDD rel19 sky130_fd_sc_hd__clkdlybuf4s25_1
XREL20 rel19 GND GND VDD VDD rel20 sky130_fd_sc_hd__clkdlybuf4s25_1
XREL21 rel20 GND GND VDD VDD rel21 sky130_fd_sc_hd__clkdlybuf4s25_1
XREL22 rel21 GND GND VDD VDD rel22 sky130_fd_sc_hd__clkdlybuf4s25_1
XREL23 rel22 GND GND VDD VDD rel23 sky130_fd_sc_hd__clkdlybuf4s25_1
XREL24 rel23 GND GND VDD VDD rel24 sky130_fd_sc_hd__clkdlybuf4s25_1
XREL25 rel24 GND GND VDD VDD rel25 sky130_fd_sc_hd__clkdlybuf4s25_1
XREL26 rel25 GND GND VDD VDD rel26 sky130_fd_sc_hd__clkdlybuf4s25_1
XREL27 rel26 GND GND VDD VDD rel27 sky130_fd_sc_hd__clkdlybuf4s25_1
XREL28 rel27 GND GND VDD VDD rel28 sky130_fd_sc_hd__clkdlybuf4s25_1
XREL29 rel28 GND GND VDD VDD rel29 sky130_fd_sc_hd__clkdlybuf4s25_1
XREL30 rel29 GND GND VDD VDD rel30 sky130_fd_sc_hd__clkdlybuf4s25_1
XREL31 rel30 GND GND VDD VDD rel31 sky130_fd_sc_hd__clkdlybuf4s25_1
XREL32 rel31 GND GND VDD VDD rel32 sky130_fd_sc_hd__clkdlybuf4s25_1
XREL33 rel32 GND GND VDD VDD rel33 sky130_fd_sc_hd__clkdlybuf4s25_1
XREL34 rel33 GND GND VDD VDD rel34 sky130_fd_sc_hd__clkdlybuf4s25_1
XREL35 rel34 GND GND VDD VDD rel35 sky130_fd_sc_hd__clkdlybuf4s25_1
XREL36 rel35 GND GND VDD VDD rel36 sky130_fd_sc_hd__clkdlybuf4s25_1
XREL37 rel36 GND GND VDD VDD rel37 sky130_fd_sc_hd__clkdlybuf4s25_1
XREL38 rel37 GND GND VDD VDD rel38 sky130_fd_sc_hd__clkdlybuf4s25_1
XREL39 rel38 GND GND VDD VDD REL sky130_fd_sc_hd__clkdlybuf4s25_1
.ends
