* generated by gen_watchdog.py; DUT subcircuits only (wdb)
.subckt wdb EN RSTB RAW TICK VDD GND
XG EN RAW GND GND VDD VDD n0 sky130_fd_sc_hd__nand2_1
XD1 n0 GND GND VDD VDD d1 sky130_fd_sc_hd__buf_1
XD2 d1 GND GND VDD VDD d2 sky130_fd_sc_hd__buf_1
XD3 d2 GND GND VDD VDD d3 sky130_fd_sc_hd__buf_1
XD4 d3 GND GND VDD VDD d4 sky130_fd_sc_hd__buf_1
XD5 d4 GND GND VDD VDD d5 sky130_fd_sc_hd__buf_1
XD6 d5 GND GND VDD VDD d6 sky130_fd_sc_hd__buf_1
XD7 d6 GND GND VDD VDD d7 sky130_fd_sc_hd__buf_1
XD8 d7 GND GND VDD VDD d8 sky130_fd_sc_hd__buf_1
XD9 d8 GND GND VDD VDD d9 sky130_fd_sc_hd__buf_1
XD10 d9 GND GND VDD VDD d10 sky130_fd_sc_hd__buf_1
XD11 d10 GND GND VDD VDD d11 sky130_fd_sc_hd__buf_1
XD12 d11 GND GND VDD VDD d12 sky130_fd_sc_hd__buf_1
XD13 d12 GND GND VDD VDD d13 sky130_fd_sc_hd__buf_1
XD14 d13 GND GND VDD VDD d14 sky130_fd_sc_hd__buf_1
XD15 d14 GND GND VDD VDD d15 sky130_fd_sc_hd__buf_1
XD16 d15 GND GND VDD VDD d16 sky130_fd_sc_hd__buf_1
XD17 d16 GND GND VDD VDD d17 sky130_fd_sc_hd__buf_1
XD18 d17 GND GND VDD VDD d18 sky130_fd_sc_hd__buf_1
XD19 d18 GND GND VDD VDD d19 sky130_fd_sc_hd__buf_1
XD20 d19 GND GND VDD VDD d20 sky130_fd_sc_hd__buf_1
XD21 d20 GND GND VDD VDD d21 sky130_fd_sc_hd__buf_1
XD22 d21 GND GND VDD VDD d22 sky130_fd_sc_hd__buf_1
XD23 d22 GND GND VDD VDD d23 sky130_fd_sc_hd__buf_1
XD24 d23 GND GND VDD VDD d24 sky130_fd_sc_hd__buf_1
XD25 d24 GND GND VDD VDD d25 sky130_fd_sc_hd__buf_1
XD26 d25 GND GND VDD VDD d26 sky130_fd_sc_hd__buf_1
XD27 d26 GND GND VDD VDD d27 sky130_fd_sc_hd__buf_1
XD28 d27 GND GND VDD VDD d28 sky130_fd_sc_hd__buf_1
XD29 d28 GND GND VDD VDD RAW sky130_fd_sc_hd__buf_1
XF1 RAW qn1 RSTB GND GND VDD VDD q1 qn1 sky130_fd_sc_hd__dfrbp_1
XF2 q1 qn2 RSTB GND GND VDD VDD q2 qn2 sky130_fd_sc_hd__dfrbp_1
XF3 q2 qn3 RSTB GND GND VDD VDD q3 qn3 sky130_fd_sc_hd__dfrbp_1
XF4 q3 qn4 RSTB GND GND VDD VDD q4 qn4 sky130_fd_sc_hd__dfrbp_1
XF5 q4 qn5 RSTB GND GND VDD VDD q5 qn5 sky130_fd_sc_hd__dfrbp_1
XF6 q5 qn6 RSTB GND GND VDD VDD TICK qn6 sky130_fd_sc_hd__dfrbp_1
.ends
